* NGSPICE file created from analog_switch_med.ext - technology: ihp-sg13cmos5l

.subckt sg13cmos5l_antennanp A VDD VSS
X0 A VDD dpantenna l=1.34u w=1.05u
X1 VSS A dantenna l=0.78u w=0.78u
.ends

.subckt sg13_hv_pmos_3CJ4LL B D0_0 G D0_1 D0_2 D0_3 S1_0 S1_1 S1_2 S1_3 D2_0 D2_1
+ D2_2 D2_3 S3_0 S3_1 S3_2 S3_3 D4_0 D4_1 D4_2 D4_3 S5_0 S5_1 S5_2 S5_3 D6_0 D6_1
+ D6_2 D6_3 S7_0 S7_1 S7_2 S7_3 D8_0 D8_1 D8_2 D8_3 S9_0 S9_1 S9_2 S9_3 a_1048_44#
+ a_1048_n4132# a_1048_n2044# a_1048_2132#
X0 a_1048_2132# G S9_3 B sg13_hv_pmos ad=6.8p pd=21.36u as=3.6p ps=10.72u w=10u l=0.4u
X1 S7_1 G D6_1 B sg13_hv_pmos ad=3.6p pd=10.72u as=3.6p ps=10.72u w=10u l=0.4u
X2 D6_3 G S5_3 B sg13_hv_pmos ad=3.6p pd=10.72u as=3.6p ps=10.72u w=10u l=0.4u
X3 D2_1 G S1_1 B sg13_hv_pmos ad=3.6p pd=10.72u as=3.6p ps=10.72u w=10u l=0.4u
X4 S9_3 G D8_3 B sg13_hv_pmos ad=3.6p pd=10.72u as=3.6p ps=10.72u w=10u l=0.4u
X5 S3_0 G D2_0 B sg13_hv_pmos ad=3.6p pd=10.72u as=3.6p ps=10.72u w=10u l=0.4u
X6 D8_3 G S7_3 B sg13_hv_pmos ad=3.6p pd=10.72u as=3.6p ps=10.72u w=10u l=0.4u
X7 D6_2 G S5_2 B sg13_hv_pmos ad=3.6p pd=10.72u as=3.6p ps=10.72u w=10u l=0.4u
X8 S1_1 G D0_1 B sg13_hv_pmos ad=3.6p pd=10.72u as=6.8p ps=21.36u w=10u l=0.4u
X9 a_1048_44# G S9_2 B sg13_hv_pmos ad=6.8p pd=21.36u as=3.6p ps=10.72u w=10u l=0.4u
X10 D6_1 G S5_1 B sg13_hv_pmos ad=3.6p pd=10.72u as=3.6p ps=10.72u w=10u l=0.4u
X11 D8_1 G S7_1 B sg13_hv_pmos ad=3.6p pd=10.72u as=3.6p ps=10.72u w=10u l=0.4u
X12 S7_3 G D6_3 B sg13_hv_pmos ad=3.6p pd=10.72u as=3.6p ps=10.72u w=10u l=0.4u
X13 S3_2 G D2_2 B sg13_hv_pmos ad=3.6p pd=10.72u as=3.6p ps=10.72u w=10u l=0.4u
X14 S7_0 G D6_0 B sg13_hv_pmos ad=3.6p pd=10.72u as=3.6p ps=10.72u w=10u l=0.4u
X15 D2_0 G S1_0 B sg13_hv_pmos ad=3.6p pd=10.72u as=3.6p ps=10.72u w=10u l=0.4u
X16 S9_1 G D8_1 B sg13_hv_pmos ad=3.6p pd=10.72u as=3.6p ps=10.72u w=10u l=0.4u
X17 S1_0 G D0_0 B sg13_hv_pmos ad=3.6p pd=10.72u as=6.8p ps=21.36u w=10u l=0.4u
X18 D2_2 G S1_2 B sg13_hv_pmos ad=3.6p pd=10.72u as=3.6p ps=10.72u w=10u l=0.4u
X19 S9_2 G D8_2 B sg13_hv_pmos ad=3.6p pd=10.72u as=3.6p ps=10.72u w=10u l=0.4u
X20 a_1048_n2044# G S9_1 B sg13_hv_pmos ad=6.8p pd=21.36u as=3.6p ps=10.72u w=10u l=0.4u
X21 D6_0 G S5_0 B sg13_hv_pmos ad=3.6p pd=10.72u as=3.6p ps=10.72u w=10u l=0.4u
X22 D8_0 G S7_0 B sg13_hv_pmos ad=3.6p pd=10.72u as=3.6p ps=10.72u w=10u l=0.4u
X23 S1_3 G D0_3 B sg13_hv_pmos ad=3.6p pd=10.72u as=6.8p ps=21.36u w=10u l=0.4u
X24 D4_2 G S3_2 B sg13_hv_pmos ad=3.6p pd=10.72u as=3.6p ps=10.72u w=10u l=0.4u
X25 S5_1 G D4_1 B sg13_hv_pmos ad=3.6p pd=10.72u as=3.6p ps=10.72u w=10u l=0.4u
X26 D2_3 G S1_3 B sg13_hv_pmos ad=3.6p pd=10.72u as=3.6p ps=10.72u w=10u l=0.4u
X27 S1_2 G D0_2 B sg13_hv_pmos ad=3.6p pd=10.72u as=6.8p ps=21.36u w=10u l=0.4u
X28 S7_2 G D6_2 B sg13_hv_pmos ad=3.6p pd=10.72u as=3.6p ps=10.72u w=10u l=0.4u
X29 S9_0 G D8_0 B sg13_hv_pmos ad=3.6p pd=10.72u as=3.6p ps=10.72u w=10u l=0.4u
X30 S3_3 G D2_3 B sg13_hv_pmos ad=3.6p pd=10.72u as=3.6p ps=10.72u w=10u l=0.4u
X31 D4_1 G S3_1 B sg13_hv_pmos ad=3.6p pd=10.72u as=3.6p ps=10.72u w=10u l=0.4u
X32 a_1048_n4132# G S9_0 B sg13_hv_pmos ad=6.8p pd=21.36u as=3.6p ps=10.72u w=10u l=0.4u
X33 D4_3 G S3_3 B sg13_hv_pmos ad=3.6p pd=10.72u as=3.6p ps=10.72u w=10u l=0.4u
X34 D8_2 G S7_2 B sg13_hv_pmos ad=3.6p pd=10.72u as=3.6p ps=10.72u w=10u l=0.4u
X35 S5_0 G D4_0 B sg13_hv_pmos ad=3.6p pd=10.72u as=3.6p ps=10.72u w=10u l=0.4u
X36 S3_1 G D2_1 B sg13_hv_pmos ad=3.6p pd=10.72u as=3.6p ps=10.72u w=10u l=0.4u
X37 S5_2 G D4_2 B sg13_hv_pmos ad=3.6p pd=10.72u as=3.6p ps=10.72u w=10u l=0.4u
X38 S5_3 G D4_3 B sg13_hv_pmos ad=3.6p pd=10.72u as=3.6p ps=10.72u w=10u l=0.4u
X39 D4_0 G S3_0 B sg13_hv_pmos ad=3.6p pd=10.72u as=3.6p ps=10.72u w=10u l=0.4u
.ends

.subckt sg13_hv_nmos_VCL2HP D0 G0 S1 G1 D2 G2 S3 G3 D4 G4 S5 G5 D6 G6 S7 G7 D8 G8
+ S9 G9 D10 G10 S11 G11 D12 G12 S13 G13 D14 G14 S15 G15 D16 G16 S17 G17 D18 G18 S19
+ G19 D20 G20 S21 G21 D22 G22 S23 G23 D24 G24 S25 G25 D26 G26 S27 G27 D28 G28 S29
+ G29 D30 G30 S31 G31 D32 G32 S33 G33 D34 G34 S35 G35 D36 G36 S37 G37 D38 G38 S39
+ G39 sub a_3482_n500#
X0 S3 G2 D2 sub sg13_hv_nmos ad=0.95p pd=5.38u as=0.95p ps=5.38u w=5u l=0.5u
X1 D22 G21 S21 sub sg13_hv_nmos ad=0.95p pd=5.38u as=0.95p ps=5.38u w=5u l=0.5u
X2 D18 G17 S17 sub sg13_hv_nmos ad=0.95p pd=5.38u as=0.95p ps=5.38u w=5u l=0.5u
X3 D32 G31 S31 sub sg13_hv_nmos ad=0.95p pd=5.38u as=0.95p ps=5.38u w=5u l=0.5u
X4 D2 G1 S1 sub sg13_hv_nmos ad=0.95p pd=5.38u as=0.95p ps=5.38u w=5u l=0.5u
X5 S39 G38 D38 sub sg13_hv_nmos ad=0.95p pd=5.38u as=0.95p ps=5.38u w=5u l=0.5u
X6 S17 G16 D16 sub sg13_hv_nmos ad=0.95p pd=5.38u as=0.95p ps=5.38u w=5u l=0.5u
X7 D8 G7 S7 sub sg13_hv_nmos ad=0.95p pd=5.38u as=0.95p ps=5.38u w=5u l=0.5u
X8 S15 G14 D14 sub sg13_hv_nmos ad=0.95p pd=5.38u as=0.95p ps=5.38u w=5u l=0.5u
X9 D24 G23 S23 sub sg13_hv_nmos ad=0.95p pd=5.38u as=0.95p ps=5.38u w=5u l=0.5u
X10 D38 G37 S37 sub sg13_hv_nmos ad=0.95p pd=5.38u as=0.95p ps=5.38u w=5u l=0.5u
X11 D26 G25 S25 sub sg13_hv_nmos ad=0.95p pd=5.38u as=0.95p ps=5.38u w=5u l=0.5u
X12 D16 G15 S15 sub sg13_hv_nmos ad=0.95p pd=5.38u as=0.95p ps=5.38u w=5u l=0.5u
X13 S9 G8 D8 sub sg13_hv_nmos ad=0.95p pd=5.38u as=0.95p ps=5.38u w=5u l=0.5u
X14 S23 G22 D22 sub sg13_hv_nmos ad=0.95p pd=5.38u as=0.95p ps=5.38u w=5u l=0.5u
X15 D34 G33 S33 sub sg13_hv_nmos ad=0.95p pd=5.38u as=0.95p ps=5.38u w=5u l=0.5u
X16 S7 G6 D6 sub sg13_hv_nmos ad=0.95p pd=5.38u as=0.95p ps=5.38u w=5u l=0.5u
X17 S25 G24 D24 sub sg13_hv_nmos ad=0.95p pd=5.38u as=0.95p ps=5.38u w=5u l=0.5u
X18 S13 G12 D12 sub sg13_hv_nmos ad=0.95p pd=5.38u as=0.95p ps=5.38u w=5u l=0.5u
X19 S33 G32 D32 sub sg13_hv_nmos ad=0.95p pd=5.38u as=0.95p ps=5.38u w=5u l=0.5u
X20 S1 G0 D0 sub sg13_hv_nmos ad=0.95p pd=5.38u as=1.7p ps=10.68u w=5u l=0.5u
X21 D6 G5 S5 sub sg13_hv_nmos ad=0.95p pd=5.38u as=0.95p ps=5.38u w=5u l=0.5u
X22 S21 G20 D20 sub sg13_hv_nmos ad=0.95p pd=5.38u as=0.95p ps=5.38u w=5u l=0.5u
X23 S35 G34 D34 sub sg13_hv_nmos ad=0.95p pd=5.38u as=0.95p ps=5.38u w=5u l=0.5u
X24 a_3482_n500# G39 S39 sub sg13_hv_nmos ad=1.7p pd=10.68u as=0.95p ps=5.38u w=5u l=0.5u
X25 D14 G13 S13 sub sg13_hv_nmos ad=0.95p pd=5.38u as=0.95p ps=5.38u w=5u l=0.5u
X26 S27 G26 D26 sub sg13_hv_nmos ad=0.95p pd=5.38u as=0.95p ps=5.38u w=5u l=0.5u
X27 S29 G28 D28 sub sg13_hv_nmos ad=0.95p pd=5.38u as=0.95p ps=5.38u w=5u l=0.5u
X28 S5 G4 D4 sub sg13_hv_nmos ad=0.95p pd=5.38u as=0.95p ps=5.38u w=5u l=0.5u
X29 D12 G11 S11 sub sg13_hv_nmos ad=0.95p pd=5.38u as=0.95p ps=5.38u w=5u l=0.5u
X30 D36 G35 S35 sub sg13_hv_nmos ad=0.95p pd=5.38u as=0.95p ps=5.38u w=5u l=0.5u
X31 D28 G27 S27 sub sg13_hv_nmos ad=0.95p pd=5.38u as=0.95p ps=5.38u w=5u l=0.5u
X32 D4 G3 S3 sub sg13_hv_nmos ad=0.95p pd=5.38u as=0.95p ps=5.38u w=5u l=0.5u
X33 S11 G10 D10 sub sg13_hv_nmos ad=0.95p pd=5.38u as=0.95p ps=5.38u w=5u l=0.5u
X34 D20 G19 S19 sub sg13_hv_nmos ad=0.95p pd=5.38u as=0.95p ps=5.38u w=5u l=0.5u
X35 D30 G29 S29 sub sg13_hv_nmos ad=0.95p pd=5.38u as=0.95p ps=5.38u w=5u l=0.5u
X36 S37 G36 D36 sub sg13_hv_nmos ad=0.95p pd=5.38u as=0.95p ps=5.38u w=5u l=0.5u
X37 D10 G9 S9 sub sg13_hv_nmos ad=0.95p pd=5.38u as=0.95p ps=5.38u w=5u l=0.5u
X38 S19 G18 D18 sub sg13_hv_nmos ad=0.95p pd=5.38u as=0.95p ps=5.38u w=5u l=0.5u
X39 S31 G30 D30 sub sg13_hv_nmos ad=0.95p pd=5.38u as=0.95p ps=5.38u w=5u l=0.5u
.ends

.subckt sg13_hv_pmos_G9ZGU3 D0 G0 S1 G1 D2 G2 S3 G3 D4 G4 S5 G5 D6 G6 S7 G7 D8 G8
+ S9 G9 D10 G10 S11 G11 D12 G12 S13 G13 D14 G14 S15 G15 D16 G16 S17 G17 D18 G18 S19
+ G19 D20 G20 S21 G21 D22 G22 S23 G23 D24 G24 S25 G25 D26 G26 S27 G27 D28 G28 S29
+ G29 D30 G30 S31 G31 D32 G32 S33 G33 D34 G34 S35 G35 D36 G36 S37 G37 D38 G38 S39
+ G39 w_n3674_n1124# a_3482_n1000#
X0 D6 G5 S5 w_n3674_n1124# sg13_hv_pmos ad=1.9p pd=10.38u as=1.9p ps=10.38u w=10u l=0.5u
X1 S13 G12 D12 w_n3674_n1124# sg13_hv_pmos ad=1.9p pd=10.38u as=1.9p ps=10.38u w=10u l=0.5u
X2 S21 G20 D20 w_n3674_n1124# sg13_hv_pmos ad=1.9p pd=10.38u as=1.9p ps=10.38u w=10u l=0.5u
X3 S33 G32 D32 w_n3674_n1124# sg13_hv_pmos ad=1.9p pd=10.38u as=1.9p ps=10.38u w=10u l=0.5u
X4 S35 G34 D34 w_n3674_n1124# sg13_hv_pmos ad=1.9p pd=10.38u as=1.9p ps=10.38u w=10u l=0.5u
X5 a_3482_n1000# G39 S39 w_n3674_n1124# sg13_hv_pmos ad=3.4p pd=20.68u as=1.9p ps=10.38u w=10u l=0.5u
X6 S1 G0 D0 w_n3674_n1124# sg13_hv_pmos ad=1.9p pd=10.38u as=3.4p ps=20.68u w=10u l=0.5u
X7 D12 G11 S11 w_n3674_n1124# sg13_hv_pmos ad=1.9p pd=10.38u as=1.9p ps=10.38u w=10u l=0.5u
X8 D14 G13 S13 w_n3674_n1124# sg13_hv_pmos ad=1.9p pd=10.38u as=1.9p ps=10.38u w=10u l=0.5u
X9 S27 G26 D26 w_n3674_n1124# sg13_hv_pmos ad=1.9p pd=10.38u as=1.9p ps=10.38u w=10u l=0.5u
X10 S29 G28 D28 w_n3674_n1124# sg13_hv_pmos ad=1.9p pd=10.38u as=1.9p ps=10.38u w=10u l=0.5u
X11 D36 G35 S35 w_n3674_n1124# sg13_hv_pmos ad=1.9p pd=10.38u as=1.9p ps=10.38u w=10u l=0.5u
X12 S5 G4 D4 w_n3674_n1124# sg13_hv_pmos ad=1.9p pd=10.38u as=1.9p ps=10.38u w=10u l=0.5u
X13 S11 G10 D10 w_n3674_n1124# sg13_hv_pmos ad=1.9p pd=10.38u as=1.9p ps=10.38u w=10u l=0.5u
X14 D20 G19 S19 w_n3674_n1124# sg13_hv_pmos ad=1.9p pd=10.38u as=1.9p ps=10.38u w=10u l=0.5u
X15 D28 G27 S27 w_n3674_n1124# sg13_hv_pmos ad=1.9p pd=10.38u as=1.9p ps=10.38u w=10u l=0.5u
X16 D30 G29 S29 w_n3674_n1124# sg13_hv_pmos ad=1.9p pd=10.38u as=1.9p ps=10.38u w=10u l=0.5u
X17 D4 G3 S3 w_n3674_n1124# sg13_hv_pmos ad=1.9p pd=10.38u as=1.9p ps=10.38u w=10u l=0.5u
X18 S37 G36 D36 w_n3674_n1124# sg13_hv_pmos ad=1.9p pd=10.38u as=1.9p ps=10.38u w=10u l=0.5u
X19 S31 G30 D30 w_n3674_n1124# sg13_hv_pmos ad=1.9p pd=10.38u as=1.9p ps=10.38u w=10u l=0.5u
X20 D10 G9 S9 w_n3674_n1124# sg13_hv_pmos ad=1.9p pd=10.38u as=1.9p ps=10.38u w=10u l=0.5u
X21 S19 G18 D18 w_n3674_n1124# sg13_hv_pmos ad=1.9p pd=10.38u as=1.9p ps=10.38u w=10u l=0.5u
X22 D22 G21 S21 w_n3674_n1124# sg13_hv_pmos ad=1.9p pd=10.38u as=1.9p ps=10.38u w=10u l=0.5u
X23 S3 G2 D2 w_n3674_n1124# sg13_hv_pmos ad=1.9p pd=10.38u as=1.9p ps=10.38u w=10u l=0.5u
X24 D18 G17 S17 w_n3674_n1124# sg13_hv_pmos ad=1.9p pd=10.38u as=1.9p ps=10.38u w=10u l=0.5u
X25 D32 G31 S31 w_n3674_n1124# sg13_hv_pmos ad=1.9p pd=10.38u as=1.9p ps=10.38u w=10u l=0.5u
X26 D2 G1 S1 w_n3674_n1124# sg13_hv_pmos ad=1.9p pd=10.38u as=1.9p ps=10.38u w=10u l=0.5u
X27 S39 G38 D38 w_n3674_n1124# sg13_hv_pmos ad=1.9p pd=10.38u as=1.9p ps=10.38u w=10u l=0.5u
X28 S17 G16 D16 w_n3674_n1124# sg13_hv_pmos ad=1.9p pd=10.38u as=1.9p ps=10.38u w=10u l=0.5u
X29 S15 G14 D14 w_n3674_n1124# sg13_hv_pmos ad=1.9p pd=10.38u as=1.9p ps=10.38u w=10u l=0.5u
X30 D8 G7 S7 w_n3674_n1124# sg13_hv_pmos ad=1.9p pd=10.38u as=1.9p ps=10.38u w=10u l=0.5u
X31 D24 G23 S23 w_n3674_n1124# sg13_hv_pmos ad=1.9p pd=10.38u as=1.9p ps=10.38u w=10u l=0.5u
X32 D26 G25 S25 w_n3674_n1124# sg13_hv_pmos ad=1.9p pd=10.38u as=1.9p ps=10.38u w=10u l=0.5u
X33 D38 G37 S37 w_n3674_n1124# sg13_hv_pmos ad=1.9p pd=10.38u as=1.9p ps=10.38u w=10u l=0.5u
X34 D16 G15 S15 w_n3674_n1124# sg13_hv_pmos ad=1.9p pd=10.38u as=1.9p ps=10.38u w=10u l=0.5u
X35 S7 G6 D6 w_n3674_n1124# sg13_hv_pmos ad=1.9p pd=10.38u as=1.9p ps=10.38u w=10u l=0.5u
X36 S9 G8 D8 w_n3674_n1124# sg13_hv_pmos ad=1.9p pd=10.38u as=1.9p ps=10.38u w=10u l=0.5u
X37 S23 G22 D22 w_n3674_n1124# sg13_hv_pmos ad=1.9p pd=10.38u as=1.9p ps=10.38u w=10u l=0.5u
X38 S25 G24 D24 w_n3674_n1124# sg13_hv_pmos ad=1.9p pd=10.38u as=1.9p ps=10.38u w=10u l=0.5u
X39 D34 G33 S33 w_n3674_n1124# sg13_hv_pmos ad=1.9p pd=10.38u as=1.9p ps=10.38u w=10u l=0.5u
.ends

.subckt sg13_hv_pmos_2TUKLB D0 G0 S1 G1 w_n330_n174# a_138_n50#
X0 a_138_n50# G1 S1 w_n330_n174# sg13_hv_pmos ad=0.17p pd=1.68u as=95f ps=0.88u w=0.5u l=0.5u
X1 S1 G0 D0 w_n330_n174# sg13_hv_pmos ad=95f pd=0.88u as=0.17p ps=1.68u w=0.5u l=0.5u
.ends

.subckt sg13_hv_nmos_CJ33WB D0 S0 G0 D1 S1 G1 sub
X0 D1 G1 S1 sub sg13_hv_nmos ad=0.68p pd=4.68u as=0.68p ps=4.68u w=2u l=0.5u
X1 S0 G0 D0 sub sg13_hv_nmos ad=0.68p pd=4.68u as=0.68p ps=4.68u w=2u l=0.5u
.ends

.subckt gate_drive_med in_n in_p vdd out vss outn
Xsg13_hv_nmos_VCL2HP_0 vss sg13_hv_pmos_G9ZGU3_0/G1 sg13_hv_pmos_G9ZGU3_0/S1 sg13_hv_pmos_G9ZGU3_0/G1
+ vss sg13_hv_pmos_G9ZGU3_0/S1 sg13_hv_pmos_G9ZGU3_0/S7 sg13_hv_pmos_G9ZGU3_0/S1 vss
+ sg13_hv_pmos_G9ZGU3_0/S1 sg13_hv_pmos_G9ZGU3_0/S7 sg13_hv_pmos_G9ZGU3_0/S1 vss sg13_hv_pmos_G9ZGU3_0/S1
+ sg13_hv_pmos_G9ZGU3_0/S7 sg13_hv_pmos_G9ZGU3_0/S1 vss sg13_hv_pmos_G9ZGU3_0/S7 outn
+ sg13_hv_pmos_G9ZGU3_0/S7 vss sg13_hv_pmos_G9ZGU3_0/S7 outn sg13_hv_pmos_G9ZGU3_0/S7
+ vss sg13_hv_pmos_G9ZGU3_0/S7 outn sg13_hv_pmos_G9ZGU3_0/S7 vss sg13_hv_pmos_G9ZGU3_0/S7
+ outn sg13_hv_pmos_G9ZGU3_0/S7 vss sg13_hv_pmos_G9ZGU3_0/S7 outn sg13_hv_pmos_G9ZGU3_0/S7
+ vss sg13_hv_pmos_G9ZGU3_0/S7 outn sg13_hv_pmos_G9ZGU3_0/S7 vss sg13_hv_pmos_G9ZGU3_0/S7
+ outn sg13_hv_pmos_G9ZGU3_0/S7 vss sg13_hv_pmos_G9ZGU3_0/S7 outn sg13_hv_pmos_G9ZGU3_0/S7
+ vss outn out outn vss outn out outn vss outn out outn vss outn out outn vss outn
+ out outn vss outn out outn vss outn out outn vss outn out outn vss vss sg13_hv_nmos_VCL2HP
Xsg13_hv_pmos_G9ZGU3_0 vdd sg13_hv_pmos_G9ZGU3_0/G1 sg13_hv_pmos_G9ZGU3_0/S1 sg13_hv_pmos_G9ZGU3_0/G1
+ vdd sg13_hv_pmos_G9ZGU3_0/S1 sg13_hv_pmos_G9ZGU3_0/S7 sg13_hv_pmos_G9ZGU3_0/S1 vdd
+ sg13_hv_pmos_G9ZGU3_0/S1 sg13_hv_pmos_G9ZGU3_0/S7 sg13_hv_pmos_G9ZGU3_0/S1 vdd sg13_hv_pmos_G9ZGU3_0/S1
+ sg13_hv_pmos_G9ZGU3_0/S7 sg13_hv_pmos_G9ZGU3_0/S1 vdd sg13_hv_pmos_G9ZGU3_0/S7 outn
+ sg13_hv_pmos_G9ZGU3_0/S7 vdd sg13_hv_pmos_G9ZGU3_0/S7 outn sg13_hv_pmos_G9ZGU3_0/S7
+ vdd sg13_hv_pmos_G9ZGU3_0/S7 outn sg13_hv_pmos_G9ZGU3_0/S7 vdd sg13_hv_pmos_G9ZGU3_0/S7
+ outn sg13_hv_pmos_G9ZGU3_0/S7 vdd sg13_hv_pmos_G9ZGU3_0/S7 outn sg13_hv_pmos_G9ZGU3_0/S7
+ vdd sg13_hv_pmos_G9ZGU3_0/S7 outn sg13_hv_pmos_G9ZGU3_0/S7 vdd sg13_hv_pmos_G9ZGU3_0/S7
+ outn sg13_hv_pmos_G9ZGU3_0/S7 vdd sg13_hv_pmos_G9ZGU3_0/S7 outn sg13_hv_pmos_G9ZGU3_0/S7
+ vdd outn out outn vdd outn out outn vdd outn out outn vdd outn out outn vdd outn
+ out outn vdd outn out outn vdd outn out outn vdd outn out outn vdd vdd sg13_hv_pmos_G9ZGU3
Xsg13_hv_pmos_2TUKLB_0 sg13_hv_pmos_2TUKLB_0/G1 sg13_hv_pmos_G9ZGU3_0/G1 vdd sg13_hv_pmos_2TUKLB_0/G1
+ vdd sg13_hv_pmos_G9ZGU3_0/G1 sg13_hv_pmos_2TUKLB
Xsg13_hv_nmos_CJ33WB_0 vss sg13_hv_pmos_2TUKLB_0/G1 in_p sg13_hv_pmos_G9ZGU3_0/G1
+ vss in_n vss sg13_hv_nmos_CJ33WB
.ends

.subckt sg13_hv_nmos_9DTRBE B D0_0 G D0_1 D0_2 D0_3 S1_0 S1_1 S1_2 S1_3 D2_0 D2_1
+ D2_2 D2_3 S3_0 S3_1 S3_2 S3_3 D4_0 D4_1 D4_2 D4_3 S5_0 S5_1 S5_2 S5_3 D6_0 D6_1
+ D6_2 D6_3 S7_0 S7_1 S7_2 S7_3 D8_0 D8_1 D8_2 D8_3 S9_0 S9_1 S9_2 S9_3 a_1098_n4132#
+ a_1098_44# a_1098_n2044# a_1098_2132#
X0 D8_0 G S7_0 B sg13_hv_nmos ad=3.6p pd=10.72u as=3.6p ps=10.72u w=10u l=0.45u
X1 S5_2 G D4_2 B sg13_hv_nmos ad=3.6p pd=10.72u as=3.6p ps=10.72u w=10u l=0.45u
X2 S9_2 G D8_2 B sg13_hv_nmos ad=3.6p pd=10.72u as=3.6p ps=10.72u w=10u l=0.45u
X3 S1_3 G D0_3 B sg13_hv_nmos ad=3.6p pd=10.72u as=6.8p ps=21.36u w=10u l=0.45u
X4 D6_3 G S5_3 B sg13_hv_nmos ad=3.6p pd=10.72u as=3.6p ps=10.72u w=10u l=0.45u
X5 D2_1 G S1_1 B sg13_hv_nmos ad=3.6p pd=10.72u as=3.6p ps=10.72u w=10u l=0.45u
X6 S7_1 G D6_1 B sg13_hv_nmos ad=3.6p pd=10.72u as=3.6p ps=10.72u w=10u l=0.45u
X7 D8_2 G S7_2 B sg13_hv_nmos ad=3.6p pd=10.72u as=3.6p ps=10.72u w=10u l=0.45u
X8 S9_3 G D8_3 B sg13_hv_nmos ad=3.6p pd=10.72u as=3.6p ps=10.72u w=10u l=0.45u
X9 D2_2 G S1_2 B sg13_hv_nmos ad=3.6p pd=10.72u as=3.6p ps=10.72u w=10u l=0.45u
X10 D6_2 G S5_2 B sg13_hv_nmos ad=3.6p pd=10.72u as=3.6p ps=10.72u w=10u l=0.45u
X11 D4_3 G S3_3 B sg13_hv_nmos ad=3.6p pd=10.72u as=3.6p ps=10.72u w=10u l=0.45u
X12 D4_1 G S3_1 B sg13_hv_nmos ad=3.6p pd=10.72u as=3.6p ps=10.72u w=10u l=0.45u
X13 S1_0 G D0_0 B sg13_hv_nmos ad=3.6p pd=10.72u as=6.8p ps=21.36u w=10u l=0.45u
X14 D6_1 G S5_1 B sg13_hv_nmos ad=3.6p pd=10.72u as=3.6p ps=10.72u w=10u l=0.45u
X15 S5_1 G D4_1 B sg13_hv_nmos ad=3.6p pd=10.72u as=3.6p ps=10.72u w=10u l=0.45u
X16 D2_0 G S1_0 B sg13_hv_nmos ad=3.6p pd=10.72u as=3.6p ps=10.72u w=10u l=0.45u
X17 S7_0 G D6_0 B sg13_hv_nmos ad=3.6p pd=10.72u as=3.6p ps=10.72u w=10u l=0.45u
X18 D2_3 G S1_3 B sg13_hv_nmos ad=3.6p pd=10.72u as=3.6p ps=10.72u w=10u l=0.45u
X19 S3_1 G D2_1 B sg13_hv_nmos ad=3.6p pd=10.72u as=3.6p ps=10.72u w=10u l=0.45u
X20 D4_0 G S3_0 B sg13_hv_nmos ad=3.6p pd=10.72u as=3.6p ps=10.72u w=10u l=0.45u
X21 a_1098_2132# G S9_3 B sg13_hv_nmos ad=6.8p pd=21.36u as=3.6p ps=10.72u w=10u l=0.45u
X22 S1_2 G D0_2 B sg13_hv_nmos ad=3.6p pd=10.72u as=6.8p ps=21.36u w=10u l=0.45u
X23 D6_0 G S5_0 B sg13_hv_nmos ad=3.6p pd=10.72u as=3.6p ps=10.72u w=10u l=0.45u
X24 S3_3 G D2_3 B sg13_hv_nmos ad=3.6p pd=10.72u as=3.6p ps=10.72u w=10u l=0.45u
X25 D8_3 G S7_3 B sg13_hv_nmos ad=3.6p pd=10.72u as=3.6p ps=10.72u w=10u l=0.45u
X26 S5_0 G D4_0 B sg13_hv_nmos ad=3.6p pd=10.72u as=3.6p ps=10.72u w=10u l=0.45u
X27 S5_3 G D4_3 B sg13_hv_nmos ad=3.6p pd=10.72u as=3.6p ps=10.72u w=10u l=0.45u
X28 S9_1 G D8_1 B sg13_hv_nmos ad=3.6p pd=10.72u as=3.6p ps=10.72u w=10u l=0.45u
X29 a_1098_n2044# G S9_1 B sg13_hv_nmos ad=6.8p pd=21.36u as=3.6p ps=10.72u w=10u l=0.45u
X30 S3_0 G D2_0 B sg13_hv_nmos ad=3.6p pd=10.72u as=3.6p ps=10.72u w=10u l=0.45u
X31 S7_3 G D6_3 B sg13_hv_nmos ad=3.6p pd=10.72u as=3.6p ps=10.72u w=10u l=0.45u
X32 S7_2 G D6_2 B sg13_hv_nmos ad=3.6p pd=10.72u as=3.6p ps=10.72u w=10u l=0.45u
X33 D8_1 G S7_1 B sg13_hv_nmos ad=3.6p pd=10.72u as=3.6p ps=10.72u w=10u l=0.45u
X34 S3_2 G D2_2 B sg13_hv_nmos ad=3.6p pd=10.72u as=3.6p ps=10.72u w=10u l=0.45u
X35 a_1098_44# G S9_2 B sg13_hv_nmos ad=6.8p pd=21.36u as=3.6p ps=10.72u w=10u l=0.45u
X36 S9_0 G D8_0 B sg13_hv_nmos ad=3.6p pd=10.72u as=3.6p ps=10.72u w=10u l=0.45u
X37 D4_2 G S3_2 B sg13_hv_nmos ad=3.6p pd=10.72u as=3.6p ps=10.72u w=10u l=0.45u
X38 a_1098_n4132# G S9_0 B sg13_hv_nmos ad=6.8p pd=21.36u as=3.6p ps=10.72u w=10u l=0.45u
X39 S1_1 G D0_1 B sg13_hv_nmos ad=3.6p pd=10.72u as=6.8p ps=21.36u w=10u l=0.45u
.ends

.subckt sg13cmos5l_decap_4 VDD VSS
X0 VDD VSS VDD VDD sg13_lv_pmos ad=0.34p pd=2.68u as=2.4331p ps=11.58u w=1u l=1u
X1 VSS VDD VSS VSS sg13_lv_nmos ad=0.1428p pd=1.52u as=1.84612p ps=9.32u w=0.42u l=1u
.ends

.subckt sg13cmos5l_inv_4 Y A VDD VSS
X0 Y A VSS VSS sg13_lv_nmos ad=0.1406p pd=1.12u as=0.2516p ps=2.16u w=0.74u l=0.13u
X1 Y A VDD VDD sg13_lv_pmos ad=0.2128p pd=1.5u as=0.3808p ps=2.92u w=1.12u l=0.13u
X2 VSS A Y VSS sg13_lv_nmos ad=0.1406p pd=1.12u as=0.1406p ps=1.12u w=0.74u l=0.13u
X3 Y A VSS VSS sg13_lv_nmos ad=0.1406p pd=1.12u as=0.1406p ps=1.12u w=0.74u l=0.13u
X4 VDD A Y VDD sg13_lv_pmos ad=0.2128p pd=1.5u as=0.2128p ps=1.5u w=1.12u l=0.13u
X5 VSS A Y VSS sg13_lv_nmos ad=0.2516p pd=2.16u as=0.1406p ps=1.12u w=0.74u l=0.13u
X6 Y A VDD VDD sg13_lv_pmos ad=0.2128p pd=1.5u as=0.2128p ps=1.5u w=1.12u l=0.13u
X7 VDD A Y VDD sg13_lv_pmos ad=0.3808p pd=2.92u as=0.2128p ps=1.5u w=1.12u l=0.13u
.ends

.subckt analog_switch_med in out dvdd dvss avss enable avdd
Xsg13cmos5l_antennanp_0 enable dvdd dvss sg13cmos5l_antennanp
Xsg13_hv_pmos_3CJ4LL_0 avdd out gate_drive_med_0/outn out out out in in in in out
+ out out out in in in in out out out out in in in in out out out out in in in in
+ out out out out in in in in out out out out sg13_hv_pmos_3CJ4LL
Xgate_drive_med_0 sg13cmos5l_inv_4_1/A sg13cmos5l_inv_4_1/Y avdd gate_drive_med_0/out
+ avss gate_drive_med_0/outn gate_drive_med
Xsg13_hv_nmos_9DTRBE_0 avss out gate_drive_med_0/out out out out in in in in out out
+ out out in in in in out out out out in in in in out out out out in in in in out
+ out out out in in in in out out out out sg13_hv_nmos_9DTRBE
Xsg13cmos5l_decap_4_0 dvdd dvss sg13cmos5l_decap_4
Xsg13cmos5l_decap_4_1 dvdd dvss sg13cmos5l_decap_4
Xsg13cmos5l_inv_4_0 sg13cmos5l_inv_4_1/A enable dvdd dvss sg13cmos5l_inv_4
Xsg13cmos5l_inv_4_1 sg13cmos5l_inv_4_1/Y sg13cmos5l_inv_4_1/A dvdd dvss sg13cmos5l_inv_4
.ends
