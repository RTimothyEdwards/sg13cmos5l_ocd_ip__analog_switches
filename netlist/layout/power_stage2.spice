* NGSPICE file created from power_stage2.ext - technology: ihp-sg13cmos5l

.subckt sg13_hv_pmos_ZN7EJW B D0_0 G D0_1 D0_2 D0_3 D0_4 D0_5 D0_6 D0_7 D0_8 D0_9
+ S1_0 S1_1 S1_2 S1_3 S1_4 S1_5 S1_6 S1_7 S1_8 S1_9 D2_0 D2_1 D2_2 D2_3 D2_4 D2_5
+ D2_6 D2_7 D2_8 D2_9 S3_0 S3_1 S3_2 S3_3 S3_4 S3_5 S3_6 S3_7 S3_8 S3_9 D4_0 D4_1
+ D4_2 D4_3 D4_4 D4_5 D4_6 D4_7 D4_8 D4_9 S5_0 S5_1 S5_2 S5_3 S5_4 S5_5 S5_6 S5_7
+ S5_8 S5_9 D6_0 D6_1 D6_2 D6_3 D6_4 D6_5 D6_6 D6_7 D6_8 D6_9 S7_0 S7_1 S7_2 S7_3
+ S7_4 S7_5 S7_6 S7_7 S7_8 S7_9 D8_0 D8_1 D8_2 D8_3 D8_4 D8_5 D8_6 D8_7 D8_8 D8_9
+ S9_0 S9_1 S9_2 S9_3 S9_4 S9_5 S9_6 S9_7 S9_8 S9_9 a_1048_44# a_1048_n4132# a_1048_n8308#
+ a_1048_8396# a_1048_4220# a_1048_n10396# a_1048_n2044# a_1048_2132# a_1048_6308#
+ a_1048_n6220#
X0 a_1048_n8308# G S9_1 B sg13_hv_pmos ad=6.8p pd=21.36u as=3.6p ps=10.72u w=10u l=0.4u
X1 S3_7 G D2_7 B sg13_hv_pmos ad=3.6p pd=10.72u as=3.6p ps=10.72u w=10u l=0.4u
X2 a_1048_2132# G S9_6 B sg13_hv_pmos ad=6.8p pd=21.36u as=3.6p ps=10.72u w=10u l=0.4u
X3 S7_9 G D6_9 B sg13_hv_pmos ad=3.6p pd=10.72u as=3.6p ps=10.72u w=10u l=0.4u
X4 D4_0 G S3_0 B sg13_hv_pmos ad=3.6p pd=10.72u as=3.6p ps=10.72u w=10u l=0.4u
X5 D4_8 G S3_8 B sg13_hv_pmos ad=3.6p pd=10.72u as=3.6p ps=10.72u w=10u l=0.4u
X6 S5_1 G D4_1 B sg13_hv_pmos ad=3.6p pd=10.72u as=3.6p ps=10.72u w=10u l=0.4u
X7 S7_4 G D6_4 B sg13_hv_pmos ad=3.6p pd=10.72u as=3.6p ps=10.72u w=10u l=0.4u
X8 S1_0 G D0_0 B sg13_hv_pmos ad=3.6p pd=10.72u as=6.8p ps=21.36u w=10u l=0.4u
X9 S3_2 G D2_2 B sg13_hv_pmos ad=3.6p pd=10.72u as=3.6p ps=10.72u w=10u l=0.4u
X10 D4_7 G S3_7 B sg13_hv_pmos ad=3.6p pd=10.72u as=3.6p ps=10.72u w=10u l=0.4u
X11 a_1048_n10396# G S9_0 B sg13_hv_pmos ad=6.8p pd=21.36u as=3.6p ps=10.72u w=10u l=0.4u
X12 D2_4 G S1_4 B sg13_hv_pmos ad=3.6p pd=10.72u as=3.6p ps=10.72u w=10u l=0.4u
X13 D6_6 G S5_6 B sg13_hv_pmos ad=3.6p pd=10.72u as=3.6p ps=10.72u w=10u l=0.4u
X14 S3_3 G D2_3 B sg13_hv_pmos ad=3.6p pd=10.72u as=3.6p ps=10.72u w=10u l=0.4u
X15 S9_6 G D8_6 B sg13_hv_pmos ad=3.6p pd=10.72u as=3.6p ps=10.72u w=10u l=0.4u
X16 S5_8 G D4_8 B sg13_hv_pmos ad=3.6p pd=10.72u as=3.6p ps=10.72u w=10u l=0.4u
X17 D4_1 G S3_1 B sg13_hv_pmos ad=3.6p pd=10.72u as=3.6p ps=10.72u w=10u l=0.4u
X18 S5_7 G D4_7 B sg13_hv_pmos ad=3.6p pd=10.72u as=3.6p ps=10.72u w=10u l=0.4u
X19 S1_4 G D0_4 B sg13_hv_pmos ad=3.6p pd=10.72u as=6.8p ps=21.36u w=10u l=0.4u
X20 a_1048_6308# G S9_8 B sg13_hv_pmos ad=6.8p pd=21.36u as=3.6p ps=10.72u w=10u l=0.4u
X21 D6_5 G S5_5 B sg13_hv_pmos ad=3.6p pd=10.72u as=3.6p ps=10.72u w=10u l=0.4u
X22 S5_0 G D4_0 B sg13_hv_pmos ad=3.6p pd=10.72u as=3.6p ps=10.72u w=10u l=0.4u
X23 D8_6 G S7_6 B sg13_hv_pmos ad=3.6p pd=10.72u as=3.6p ps=10.72u w=10u l=0.4u
X24 a_1048_44# G S9_5 B sg13_hv_pmos ad=6.8p pd=21.36u as=3.6p ps=10.72u w=10u l=0.4u
X25 S7_2 G D6_2 B sg13_hv_pmos ad=3.6p pd=10.72u as=3.6p ps=10.72u w=10u l=0.4u
X26 a_1048_4220# G S9_7 B sg13_hv_pmos ad=6.8p pd=21.36u as=3.6p ps=10.72u w=10u l=0.4u
X27 S1_9 G D0_9 B sg13_hv_pmos ad=3.6p pd=10.72u as=6.8p ps=21.36u w=10u l=0.4u
X28 D8_4 G S7_4 B sg13_hv_pmos ad=3.6p pd=10.72u as=3.6p ps=10.72u w=10u l=0.4u
X29 D6_4 G S5_4 B sg13_hv_pmos ad=3.6p pd=10.72u as=3.6p ps=10.72u w=10u l=0.4u
X30 S9_0 G D8_0 B sg13_hv_pmos ad=3.6p pd=10.72u as=3.6p ps=10.72u w=10u l=0.4u
X31 D2_2 G S1_2 B sg13_hv_pmos ad=3.6p pd=10.72u as=3.6p ps=10.72u w=10u l=0.4u
X32 D6_8 G S5_8 B sg13_hv_pmos ad=3.6p pd=10.72u as=3.6p ps=10.72u w=10u l=0.4u
X33 S7_3 G D6_3 B sg13_hv_pmos ad=3.6p pd=10.72u as=3.6p ps=10.72u w=10u l=0.4u
X34 S3_5 G D2_5 B sg13_hv_pmos ad=3.6p pd=10.72u as=3.6p ps=10.72u w=10u l=0.4u
X35 S3_1 G D2_1 B sg13_hv_pmos ad=3.6p pd=10.72u as=3.6p ps=10.72u w=10u l=0.4u
X36 S9_8 G D8_8 B sg13_hv_pmos ad=3.6p pd=10.72u as=3.6p ps=10.72u w=10u l=0.4u
X37 D2_9 G S1_9 B sg13_hv_pmos ad=3.6p pd=10.72u as=3.6p ps=10.72u w=10u l=0.4u
X38 S7_6 G D6_6 B sg13_hv_pmos ad=3.6p pd=10.72u as=3.6p ps=10.72u w=10u l=0.4u
X39 D2_3 G S1_3 B sg13_hv_pmos ad=3.6p pd=10.72u as=3.6p ps=10.72u w=10u l=0.4u
X40 D6_7 G S5_7 B sg13_hv_pmos ad=3.6p pd=10.72u as=3.6p ps=10.72u w=10u l=0.4u
X41 S9_7 G D8_7 B sg13_hv_pmos ad=3.6p pd=10.72u as=3.6p ps=10.72u w=10u l=0.4u
X42 S1_2 G D0_2 B sg13_hv_pmos ad=3.6p pd=10.72u as=6.8p ps=21.36u w=10u l=0.4u
X43 S9_4 G D8_4 B sg13_hv_pmos ad=3.6p pd=10.72u as=3.6p ps=10.72u w=10u l=0.4u
X44 S3_9 G D2_9 B sg13_hv_pmos ad=3.6p pd=10.72u as=3.6p ps=10.72u w=10u l=0.4u
X45 D8_8 G S7_8 B sg13_hv_pmos ad=3.6p pd=10.72u as=3.6p ps=10.72u w=10u l=0.4u
X46 S1_3 G D0_3 B sg13_hv_pmos ad=3.6p pd=10.72u as=6.8p ps=21.36u w=10u l=0.4u
X47 S7_0 G D6_0 B sg13_hv_pmos ad=3.6p pd=10.72u as=3.6p ps=10.72u w=10u l=0.4u
X48 D8_2 G S7_2 B sg13_hv_pmos ad=3.6p pd=10.72u as=3.6p ps=10.72u w=10u l=0.4u
X49 D8_7 G S7_7 B sg13_hv_pmos ad=3.6p pd=10.72u as=3.6p ps=10.72u w=10u l=0.4u
X50 D6_2 G S5_2 B sg13_hv_pmos ad=3.6p pd=10.72u as=3.6p ps=10.72u w=10u l=0.4u
X51 D8_0 G S7_0 B sg13_hv_pmos ad=3.6p pd=10.72u as=3.6p ps=10.72u w=10u l=0.4u
X52 S7_1 G D6_1 B sg13_hv_pmos ad=3.6p pd=10.72u as=3.6p ps=10.72u w=10u l=0.4u
X53 D2_5 G S1_5 B sg13_hv_pmos ad=3.6p pd=10.72u as=3.6p ps=10.72u w=10u l=0.4u
X54 D8_3 G S7_3 B sg13_hv_pmos ad=3.6p pd=10.72u as=3.6p ps=10.72u w=10u l=0.4u
X55 D6_3 G S5_3 B sg13_hv_pmos ad=3.6p pd=10.72u as=3.6p ps=10.72u w=10u l=0.4u
X56 S7_8 G D6_8 B sg13_hv_pmos ad=3.6p pd=10.72u as=3.6p ps=10.72u w=10u l=0.4u
X57 D4_9 G S3_9 B sg13_hv_pmos ad=3.6p pd=10.72u as=3.6p ps=10.72u w=10u l=0.4u
X58 S9_5 G D8_5 B sg13_hv_pmos ad=3.6p pd=10.72u as=3.6p ps=10.72u w=10u l=0.4u
X59 D2_1 G S1_1 B sg13_hv_pmos ad=3.6p pd=10.72u as=3.6p ps=10.72u w=10u l=0.4u
X60 a_1048_n2044# G S9_4 B sg13_hv_pmos ad=6.8p pd=21.36u as=3.6p ps=10.72u w=10u l=0.4u
X61 S7_7 G D6_7 B sg13_hv_pmos ad=3.6p pd=10.72u as=3.6p ps=10.72u w=10u l=0.4u
X62 S1_6 G D0_6 B sg13_hv_pmos ad=3.6p pd=10.72u as=6.8p ps=21.36u w=10u l=0.4u
X63 S5_4 G D4_4 B sg13_hv_pmos ad=3.6p pd=10.72u as=3.6p ps=10.72u w=10u l=0.4u
X64 D4_5 G S3_5 B sg13_hv_pmos ad=3.6p pd=10.72u as=3.6p ps=10.72u w=10u l=0.4u
X65 S9_2 G D8_2 B sg13_hv_pmos ad=3.6p pd=10.72u as=3.6p ps=10.72u w=10u l=0.4u
X66 S1_5 G D0_5 B sg13_hv_pmos ad=3.6p pd=10.72u as=6.8p ps=21.36u w=10u l=0.4u
X67 S7_5 G D6_5 B sg13_hv_pmos ad=3.6p pd=10.72u as=3.6p ps=10.72u w=10u l=0.4u
X68 D2_6 G S1_6 B sg13_hv_pmos ad=3.6p pd=10.72u as=3.6p ps=10.72u w=10u l=0.4u
X69 S5_9 G D4_9 B sg13_hv_pmos ad=3.6p pd=10.72u as=3.6p ps=10.72u w=10u l=0.4u
X70 S1_1 G D0_1 B sg13_hv_pmos ad=3.6p pd=10.72u as=6.8p ps=21.36u w=10u l=0.4u
X71 S9_3 G D8_3 B sg13_hv_pmos ad=3.6p pd=10.72u as=3.6p ps=10.72u w=10u l=0.4u
X72 a_1048_8396# G S9_9 B sg13_hv_pmos ad=6.8p pd=21.36u as=3.6p ps=10.72u w=10u l=0.4u
X73 D8_1 G S7_1 B sg13_hv_pmos ad=3.6p pd=10.72u as=3.6p ps=10.72u w=10u l=0.4u
X74 D6_1 G S5_1 B sg13_hv_pmos ad=3.6p pd=10.72u as=3.6p ps=10.72u w=10u l=0.4u
X75 D4_4 G S3_4 B sg13_hv_pmos ad=3.6p pd=10.72u as=3.6p ps=10.72u w=10u l=0.4u
X76 S3_6 G D2_6 B sg13_hv_pmos ad=3.6p pd=10.72u as=3.6p ps=10.72u w=10u l=0.4u
X77 D6_0 G S5_0 B sg13_hv_pmos ad=3.6p pd=10.72u as=3.6p ps=10.72u w=10u l=0.4u
X78 a_1048_n6220# G S9_2 B sg13_hv_pmos ad=6.8p pd=21.36u as=3.6p ps=10.72u w=10u l=0.4u
X79 S1_8 G D0_8 B sg13_hv_pmos ad=3.6p pd=10.72u as=6.8p ps=21.36u w=10u l=0.4u
X80 D6_9 G S5_9 B sg13_hv_pmos ad=3.6p pd=10.72u as=3.6p ps=10.72u w=10u l=0.4u
X81 a_1048_n4132# G S9_3 B sg13_hv_pmos ad=6.8p pd=21.36u as=3.6p ps=10.72u w=10u l=0.4u
X82 S5_2 G D4_2 B sg13_hv_pmos ad=3.6p pd=10.72u as=3.6p ps=10.72u w=10u l=0.4u
X83 S9_9 G D8_9 B sg13_hv_pmos ad=3.6p pd=10.72u as=3.6p ps=10.72u w=10u l=0.4u
X84 S3_0 G D2_0 B sg13_hv_pmos ad=3.6p pd=10.72u as=3.6p ps=10.72u w=10u l=0.4u
X85 D8_5 G S7_5 B sg13_hv_pmos ad=3.6p pd=10.72u as=3.6p ps=10.72u w=10u l=0.4u
X86 S1_7 G D0_7 B sg13_hv_pmos ad=3.6p pd=10.72u as=6.8p ps=21.36u w=10u l=0.4u
X87 D2_8 G S1_8 B sg13_hv_pmos ad=3.6p pd=10.72u as=3.6p ps=10.72u w=10u l=0.4u
X88 S5_3 G D4_3 B sg13_hv_pmos ad=3.6p pd=10.72u as=3.6p ps=10.72u w=10u l=0.4u
X89 D4_6 G S3_6 B sg13_hv_pmos ad=3.6p pd=10.72u as=3.6p ps=10.72u w=10u l=0.4u
X90 D2_0 G S1_0 B sg13_hv_pmos ad=3.6p pd=10.72u as=3.6p ps=10.72u w=10u l=0.4u
X91 S9_1 G D8_1 B sg13_hv_pmos ad=3.6p pd=10.72u as=3.6p ps=10.72u w=10u l=0.4u
X92 S3_4 G D2_4 B sg13_hv_pmos ad=3.6p pd=10.72u as=3.6p ps=10.72u w=10u l=0.4u
X93 D2_7 G S1_7 B sg13_hv_pmos ad=3.6p pd=10.72u as=3.6p ps=10.72u w=10u l=0.4u
X94 S5_5 G D4_5 B sg13_hv_pmos ad=3.6p pd=10.72u as=3.6p ps=10.72u w=10u l=0.4u
X95 D8_9 G S7_9 B sg13_hv_pmos ad=3.6p pd=10.72u as=3.6p ps=10.72u w=10u l=0.4u
X96 D4_2 G S3_2 B sg13_hv_pmos ad=3.6p pd=10.72u as=3.6p ps=10.72u w=10u l=0.4u
X97 S3_8 G D2_8 B sg13_hv_pmos ad=3.6p pd=10.72u as=3.6p ps=10.72u w=10u l=0.4u
X98 S5_6 G D4_6 B sg13_hv_pmos ad=3.6p pd=10.72u as=3.6p ps=10.72u w=10u l=0.4u
X99 D4_3 G S3_3 B sg13_hv_pmos ad=3.6p pd=10.72u as=3.6p ps=10.72u w=10u l=0.4u
.ends

.subckt sg13_hv_nmos_XAVYYR D0 G0 S1 G1 D2 G2 S3 G3 sub a_314_n200#
X0 S3 G2 D2 sub sg13_hv_nmos ad=0.38p pd=2.38u as=0.38p ps=2.38u w=2u l=0.5u
X1 D2 G1 S1 sub sg13_hv_nmos ad=0.38p pd=2.38u as=0.38p ps=2.38u w=2u l=0.5u
X2 S1 G0 D0 sub sg13_hv_nmos ad=0.38p pd=2.38u as=0.68p ps=4.68u w=2u l=0.5u
X3 a_314_n200# G3 S3 sub sg13_hv_nmos ad=0.68p pd=4.68u as=0.38p ps=2.38u w=2u l=0.5u
.ends

.subckt sg13_hv_nmos_3JX36Y D0 G0 S1 G1 D2 G2 S3 G3 D4 G4 S5 G5 D6 G6 S7 G7 D8 G8
+ S9 G9 D10 G10 S11 G11 D12 G12 S13 G13 D14 G14 S15 G15 D16 G16 S17 G17 D18 G18 S19
+ G19 D20 G20 S21 G21 D22 G22 S23 G23 D24 G24 S25 G25 D26 G26 S27 G27 D28 G28 S29
+ G29 D30 G30 S31 G31 D32 G32 S33 G33 D34 G34 S35 G35 D36 G36 S37 G37 D38 G38 S39
+ G39 D40 G40 S41 G41 D42 G42 S43 G43 D44 G44 S45 G45 D46 G46 S47 G47 D48 G48 S49
+ G49 D50 G50 S51 G51 D52 G52 S53 G53 D54 G54 S55 G55 D56 G56 S57 G57 D58 G58 S59
+ G59 D60 G60 S61 G61 D62 G62 S63 G63 D64 G64 S65 G65 D66 G66 S67 G67 D68 G68 S69
+ G69 D70 G70 S71 G71 D72 G72 S73 G73 D74 G74 S75 G75 D76 G76 S77 G77 D78 G78 S79
+ G79 D80 G80 S81 G81 D82 G82 S83 G83 D84 G84 S85 G85 D86 G86 S87 G87 a_7706_n500#
+ sub
X0 S27 G26 D26 sub sg13_hv_nmos ad=0.95p pd=5.38u as=0.95p ps=5.38u w=5u l=0.5u
X1 D46 G45 S45 sub sg13_hv_nmos ad=0.95p pd=5.38u as=0.95p ps=5.38u w=5u l=0.5u
X2 D8 G7 S7 sub sg13_hv_nmos ad=0.95p pd=5.38u as=0.95p ps=5.38u w=5u l=0.5u
X3 S15 G14 D14 sub sg13_hv_nmos ad=0.95p pd=5.38u as=0.95p ps=5.38u w=5u l=0.5u
X4 D42 G41 S41 sub sg13_hv_nmos ad=0.95p pd=5.38u as=0.95p ps=5.38u w=5u l=0.5u
X5 D56 G55 S55 sub sg13_hv_nmos ad=0.95p pd=5.38u as=0.95p ps=5.38u w=5u l=0.5u
X6 D74 G73 S73 sub sg13_hv_nmos ad=0.95p pd=5.38u as=0.95p ps=5.38u w=5u l=0.5u
X7 S81 G80 D80 sub sg13_hv_nmos ad=0.95p pd=5.38u as=0.95p ps=5.38u w=5u l=0.5u
X8 D6 G5 S5 sub sg13_hv_nmos ad=0.95p pd=5.38u as=0.95p ps=5.38u w=5u l=0.5u
X9 S83 G82 D82 sub sg13_hv_nmos ad=0.95p pd=5.38u as=0.95p ps=5.38u w=5u l=0.5u
X10 S19 G18 D18 sub sg13_hv_nmos ad=0.95p pd=5.38u as=0.95p ps=5.38u w=5u l=0.5u
X11 S21 G20 D20 sub sg13_hv_nmos ad=0.95p pd=5.38u as=0.95p ps=5.38u w=5u l=0.5u
X12 D26 G25 S25 sub sg13_hv_nmos ad=0.95p pd=5.38u as=0.95p ps=5.38u w=5u l=0.5u
X13 S63 G62 D62 sub sg13_hv_nmos ad=0.95p pd=5.38u as=0.95p ps=5.38u w=5u l=0.5u
X14 D68 G67 S67 sub sg13_hv_nmos ad=0.95p pd=5.38u as=0.95p ps=5.38u w=5u l=0.5u
X15 D70 G69 S69 sub sg13_hv_nmos ad=0.95p pd=5.38u as=0.95p ps=5.38u w=5u l=0.5u
X16 D12 G11 S11 sub sg13_hv_nmos ad=0.95p pd=5.38u as=0.95p ps=5.38u w=5u l=0.5u
X17 S41 G40 D40 sub sg13_hv_nmos ad=0.95p pd=5.38u as=0.95p ps=5.38u w=5u l=0.5u
X18 D82 G81 S81 sub sg13_hv_nmos ad=0.95p pd=5.38u as=0.95p ps=5.38u w=5u l=0.5u
X19 D84 G83 S83 sub sg13_hv_nmos ad=0.95p pd=5.38u as=0.95p ps=5.38u w=5u l=0.5u
X20 D32 G31 S31 sub sg13_hv_nmos ad=0.95p pd=5.38u as=0.95p ps=5.38u w=5u l=0.5u
X21 S39 G38 D38 sub sg13_hv_nmos ad=0.95p pd=5.38u as=0.95p ps=5.38u w=5u l=0.5u
X22 D48 G47 S47 sub sg13_hv_nmos ad=0.95p pd=5.38u as=0.95p ps=5.38u w=5u l=0.5u
X23 D62 G61 S61 sub sg13_hv_nmos ad=0.95p pd=5.38u as=0.95p ps=5.38u w=5u l=0.5u
X24 S13 G12 D12 sub sg13_hv_nmos ad=0.95p pd=5.38u as=0.95p ps=5.38u w=5u l=0.5u
X25 D18 G17 S17 sub sg13_hv_nmos ad=0.95p pd=5.38u as=0.95p ps=5.38u w=5u l=0.5u
X26 D20 G19 S19 sub sg13_hv_nmos ad=0.95p pd=5.38u as=0.95p ps=5.38u w=5u l=0.5u
X27 D50 G49 S49 sub sg13_hv_nmos ad=0.95p pd=5.38u as=0.95p ps=5.38u w=5u l=0.5u
X28 S69 G68 D68 sub sg13_hv_nmos ad=0.95p pd=5.38u as=0.95p ps=5.38u w=5u l=0.5u
X29 S71 G70 D70 sub sg13_hv_nmos ad=0.95p pd=5.38u as=0.95p ps=5.38u w=5u l=0.5u
X30 D76 G75 S75 sub sg13_hv_nmos ad=0.95p pd=5.38u as=0.95p ps=5.38u w=5u l=0.5u
X31 S11 G10 D10 sub sg13_hv_nmos ad=0.95p pd=5.38u as=0.95p ps=5.38u w=5u l=0.5u
X32 D40 G39 S39 sub sg13_hv_nmos ad=0.95p pd=5.38u as=0.95p ps=5.38u w=5u l=0.5u
X33 D78 G77 S77 sub sg13_hv_nmos ad=0.95p pd=5.38u as=0.95p ps=5.38u w=5u l=0.5u
X34 S33 G32 D32 sub sg13_hv_nmos ad=0.95p pd=5.38u as=0.95p ps=5.38u w=5u l=0.5u
X35 S47 G46 D46 sub sg13_hv_nmos ad=0.95p pd=5.38u as=0.95p ps=5.38u w=5u l=0.5u
X36 D58 G57 S57 sub sg13_hv_nmos ad=0.95p pd=5.38u as=0.95p ps=5.38u w=5u l=0.5u
X37 D24 G23 S23 sub sg13_hv_nmos ad=0.95p pd=5.38u as=0.95p ps=5.38u w=5u l=0.5u
X38 S31 G30 D30 sub sg13_hv_nmos ad=0.95p pd=5.38u as=0.95p ps=5.38u w=5u l=0.5u
X39 S49 G48 D48 sub sg13_hv_nmos ad=0.95p pd=5.38u as=0.95p ps=5.38u w=5u l=0.5u
X40 S65 G64 D64 sub sg13_hv_nmos ad=0.95p pd=5.38u as=0.95p ps=5.38u w=5u l=0.5u
X41 S17 G16 D16 sub sg13_hv_nmos ad=0.95p pd=5.38u as=0.95p ps=5.38u w=5u l=0.5u
X42 S77 G76 D76 sub sg13_hv_nmos ad=0.95p pd=5.38u as=0.95p ps=5.38u w=5u l=0.5u
X43 S37 G36 D36 sub sg13_hv_nmos ad=0.95p pd=5.38u as=0.95p ps=5.38u w=5u l=0.5u
X44 S57 G56 D56 sub sg13_hv_nmos ad=0.95p pd=5.38u as=0.95p ps=5.38u w=5u l=0.5u
X45 S5 G4 D4 sub sg13_hv_nmos ad=0.95p pd=5.38u as=0.95p ps=5.38u w=5u l=0.5u
X46 S23 G22 D22 sub sg13_hv_nmos ad=0.95p pd=5.38u as=0.95p ps=5.38u w=5u l=0.5u
X47 S25 G24 D24 sub sg13_hv_nmos ad=0.95p pd=5.38u as=0.95p ps=5.38u w=5u l=0.5u
X48 D30 G29 S29 sub sg13_hv_nmos ad=0.95p pd=5.38u as=0.95p ps=5.38u w=5u l=0.5u
X49 S45 G44 D44 sub sg13_hv_nmos ad=0.95p pd=5.38u as=0.95p ps=5.38u w=5u l=0.5u
X50 S59 G58 D58 sub sg13_hv_nmos ad=0.95p pd=5.38u as=0.95p ps=5.38u w=5u l=0.5u
X51 D64 G63 S63 sub sg13_hv_nmos ad=0.95p pd=5.38u as=0.95p ps=5.38u w=5u l=0.5u
X52 D66 G65 S65 sub sg13_hv_nmos ad=0.95p pd=5.38u as=0.95p ps=5.38u w=5u l=0.5u
X53 S73 G72 D72 sub sg13_hv_nmos ad=0.95p pd=5.38u as=0.95p ps=5.38u w=5u l=0.5u
X54 D38 G37 S37 sub sg13_hv_nmos ad=0.95p pd=5.38u as=0.95p ps=5.38u w=5u l=0.5u
X55 S51 G50 D50 sub sg13_hv_nmos ad=0.95p pd=5.38u as=0.95p ps=5.38u w=5u l=0.5u
X56 S53 G52 D52 sub sg13_hv_nmos ad=0.95p pd=5.38u as=0.95p ps=5.38u w=5u l=0.5u
X57 D4 G3 S3 sub sg13_hv_nmos ad=0.95p pd=5.38u as=0.95p ps=5.38u w=5u l=0.5u
X58 S29 G28 D28 sub sg13_hv_nmos ad=0.95p pd=5.38u as=0.95p ps=5.38u w=5u l=0.5u
X59 D36 G35 S35 sub sg13_hv_nmos ad=0.95p pd=5.38u as=0.95p ps=5.38u w=5u l=0.5u
X60 D60 G59 S59 sub sg13_hv_nmos ad=0.95p pd=5.38u as=0.95p ps=5.38u w=5u l=0.5u
X61 S85 G84 D84 sub sg13_hv_nmos ad=0.95p pd=5.38u as=0.95p ps=5.38u w=5u l=0.5u
X62 D2 G1 S1 sub sg13_hv_nmos ad=0.95p pd=5.38u as=0.95p ps=5.38u w=5u l=0.5u
X63 S67 G66 D66 sub sg13_hv_nmos ad=0.95p pd=5.38u as=0.95p ps=5.38u w=5u l=0.5u
X64 D72 G71 S71 sub sg13_hv_nmos ad=0.95p pd=5.38u as=0.95p ps=5.38u w=5u l=0.5u
X65 D22 G21 S21 sub sg13_hv_nmos ad=0.95p pd=5.38u as=0.95p ps=5.38u w=5u l=0.5u
X66 D52 G51 S51 sub sg13_hv_nmos ad=0.95p pd=5.38u as=0.95p ps=5.38u w=5u l=0.5u
X67 S3 G2 D2 sub sg13_hv_nmos ad=0.95p pd=5.38u as=0.95p ps=5.38u w=5u l=0.5u
X68 D10 G9 S9 sub sg13_hv_nmos ad=0.95p pd=5.38u as=0.95p ps=5.38u w=5u l=0.5u
X69 D28 G27 S27 sub sg13_hv_nmos ad=0.95p pd=5.38u as=0.95p ps=5.38u w=5u l=0.5u
X70 S35 G34 D34 sub sg13_hv_nmos ad=0.95p pd=5.38u as=0.95p ps=5.38u w=5u l=0.5u
X71 D44 G43 S43 sub sg13_hv_nmos ad=0.95p pd=5.38u as=0.95p ps=5.38u w=5u l=0.5u
X72 D54 G53 S53 sub sg13_hv_nmos ad=0.95p pd=5.38u as=0.95p ps=5.38u w=5u l=0.5u
X73 S61 G60 D60 sub sg13_hv_nmos ad=0.95p pd=5.38u as=0.95p ps=5.38u w=5u l=0.5u
X74 S79 G78 D78 sub sg13_hv_nmos ad=0.95p pd=5.38u as=0.95p ps=5.38u w=5u l=0.5u
X75 D86 G85 S85 sub sg13_hv_nmos ad=0.95p pd=5.38u as=0.95p ps=5.38u w=5u l=0.5u
X76 S1 G0 D0 sub sg13_hv_nmos ad=0.95p pd=5.38u as=1.7p ps=10.68u w=5u l=0.5u
X77 a_7706_n500# G87 S87 sub sg13_hv_nmos ad=1.7p pd=10.68u as=0.95p ps=5.38u w=5u l=0.5u
X78 S9 G8 D8 sub sg13_hv_nmos ad=0.95p pd=5.38u as=0.95p ps=5.38u w=5u l=0.5u
X79 D14 G13 S13 sub sg13_hv_nmos ad=0.95p pd=5.38u as=0.95p ps=5.38u w=5u l=0.5u
X80 D16 G15 S15 sub sg13_hv_nmos ad=0.95p pd=5.38u as=0.95p ps=5.38u w=5u l=0.5u
X81 D34 G33 S33 sub sg13_hv_nmos ad=0.95p pd=5.38u as=0.95p ps=5.38u w=5u l=0.5u
X82 S43 G42 D42 sub sg13_hv_nmos ad=0.95p pd=5.38u as=0.95p ps=5.38u w=5u l=0.5u
X83 S55 G54 D54 sub sg13_hv_nmos ad=0.95p pd=5.38u as=0.95p ps=5.38u w=5u l=0.5u
X84 S75 G74 D74 sub sg13_hv_nmos ad=0.95p pd=5.38u as=0.95p ps=5.38u w=5u l=0.5u
X85 D80 G79 S79 sub sg13_hv_nmos ad=0.95p pd=5.38u as=0.95p ps=5.38u w=5u l=0.5u
X86 S7 G6 D6 sub sg13_hv_nmos ad=0.95p pd=5.38u as=0.95p ps=5.38u w=5u l=0.5u
X87 S87 G86 D86 sub sg13_hv_nmos ad=0.95p pd=5.38u as=0.95p ps=5.38u w=5u l=0.5u
.ends

.subckt sg13_hv_pmos_YZSTZS D0 G0 S1 G1 D2 G2 S3 G3 a_314_n400# w_n506_n524#
X0 D2 G1 S1 w_n506_n524# sg13_hv_pmos ad=0.76p pd=4.38u as=0.76p ps=4.38u w=4u l=0.5u
X1 S1 G0 D0 w_n506_n524# sg13_hv_pmos ad=0.76p pd=4.38u as=1.36p ps=8.68u w=4u l=0.5u
X2 a_314_n400# G3 S3 w_n506_n524# sg13_hv_pmos ad=1.36p pd=8.68u as=0.76p ps=4.38u w=4u l=0.5u
X3 S3 G2 D2 w_n506_n524# sg13_hv_pmos ad=0.76p pd=4.38u as=0.76p ps=4.38u w=4u l=0.5u
.ends

.subckt sg13_hv_pmos_RQMCRC D0 G0 S1 G1 D2 G2 S3 G3 D4 G4 S5 G5 D6 G6 S7 G7 D8 G8
+ S9 G9 D10 G10 S11 G11 D12 G12 S13 G13 D14 G14 S15 G15 D16 G16 S17 G17 D18 G18 S19
+ G19 D20 G20 S21 G21 D22 G22 S23 G23 D24 G24 S25 G25 D26 G26 S27 G27 D28 G28 S29
+ G29 D30 G30 S31 G31 D32 G32 S33 G33 D34 G34 S35 G35 D36 G36 S37 G37 D38 G38 S39
+ G39 D40 G40 S41 G41 D42 G42 S43 G43 D44 G44 S45 G45 D46 G46 S47 G47 D48 G48 S49
+ G49 D50 G50 S51 G51 D52 G52 S53 G53 D54 G54 S55 G55 D56 G56 S57 G57 D58 G58 S59
+ G59 D60 G60 S61 G61 D62 G62 S63 G63 D64 G64 S65 G65 D66 G66 S67 G67 D68 G68 S69
+ G69 D70 G70 S71 G71 D72 G72 S73 G73 D74 G74 S75 G75 D76 G76 S77 G77 D78 G78 S79
+ G79 D80 G80 S81 G81 D82 G82 S83 G83 D84 G84 S85 G85 D86 G86 S87 G87 w_n7898_n1124#
+ a_7706_n1000#
X0 D30 G29 S29 w_n7898_n1124# sg13_hv_pmos ad=1.9p pd=10.38u as=1.9p ps=10.38u w=10u l=0.5u
X1 S37 G36 D36 w_n7898_n1124# sg13_hv_pmos ad=1.9p pd=10.38u as=1.9p ps=10.38u w=10u l=0.5u
X2 S45 G44 D44 w_n7898_n1124# sg13_hv_pmos ad=1.9p pd=10.38u as=1.9p ps=10.38u w=10u l=0.5u
X3 S57 G56 D56 w_n7898_n1124# sg13_hv_pmos ad=1.9p pd=10.38u as=1.9p ps=10.38u w=10u l=0.5u
X4 S59 G58 D58 w_n7898_n1124# sg13_hv_pmos ad=1.9p pd=10.38u as=1.9p ps=10.38u w=10u l=0.5u
X5 D64 G63 S63 w_n7898_n1124# sg13_hv_pmos ad=1.9p pd=10.38u as=1.9p ps=10.38u w=10u l=0.5u
X6 S5 G4 D4 w_n7898_n1124# sg13_hv_pmos ad=1.9p pd=10.38u as=1.9p ps=10.38u w=10u l=0.5u
X7 S23 G22 D22 w_n7898_n1124# sg13_hv_pmos ad=1.9p pd=10.38u as=1.9p ps=10.38u w=10u l=0.5u
X8 S25 G24 D24 w_n7898_n1124# sg13_hv_pmos ad=1.9p pd=10.38u as=1.9p ps=10.38u w=10u l=0.5u
X9 D66 G65 S65 w_n7898_n1124# sg13_hv_pmos ad=1.9p pd=10.38u as=1.9p ps=10.38u w=10u l=0.5u
X10 S73 G72 D72 w_n7898_n1124# sg13_hv_pmos ad=1.9p pd=10.38u as=1.9p ps=10.38u w=10u l=0.5u
X11 D36 G35 S35 w_n7898_n1124# sg13_hv_pmos ad=1.9p pd=10.38u as=1.9p ps=10.38u w=10u l=0.5u
X12 D38 G37 S37 w_n7898_n1124# sg13_hv_pmos ad=1.9p pd=10.38u as=1.9p ps=10.38u w=10u l=0.5u
X13 S51 G50 D50 w_n7898_n1124# sg13_hv_pmos ad=1.9p pd=10.38u as=1.9p ps=10.38u w=10u l=0.5u
X14 S53 G52 D52 w_n7898_n1124# sg13_hv_pmos ad=1.9p pd=10.38u as=1.9p ps=10.38u w=10u l=0.5u
X15 D60 G59 S59 w_n7898_n1124# sg13_hv_pmos ad=1.9p pd=10.38u as=1.9p ps=10.38u w=10u l=0.5u
X16 D2 G1 S1 w_n7898_n1124# sg13_hv_pmos ad=1.9p pd=10.38u as=1.9p ps=10.38u w=10u l=0.5u
X17 D4 G3 S3 w_n7898_n1124# sg13_hv_pmos ad=1.9p pd=10.38u as=1.9p ps=10.38u w=10u l=0.5u
X18 S29 G28 D28 w_n7898_n1124# sg13_hv_pmos ad=1.9p pd=10.38u as=1.9p ps=10.38u w=10u l=0.5u
X19 S67 G66 D66 w_n7898_n1124# sg13_hv_pmos ad=1.9p pd=10.38u as=1.9p ps=10.38u w=10u l=0.5u
X20 D72 G71 S71 w_n7898_n1124# sg13_hv_pmos ad=1.9p pd=10.38u as=1.9p ps=10.38u w=10u l=0.5u
X21 S85 G84 D84 w_n7898_n1124# sg13_hv_pmos ad=1.9p pd=10.38u as=1.9p ps=10.38u w=10u l=0.5u
X22 D22 G21 S21 w_n7898_n1124# sg13_hv_pmos ad=1.9p pd=10.38u as=1.9p ps=10.38u w=10u l=0.5u
X23 S35 G34 D34 w_n7898_n1124# sg13_hv_pmos ad=1.9p pd=10.38u as=1.9p ps=10.38u w=10u l=0.5u
X24 D44 G43 S43 w_n7898_n1124# sg13_hv_pmos ad=1.9p pd=10.38u as=1.9p ps=10.38u w=10u l=0.5u
X25 D52 G51 S51 w_n7898_n1124# sg13_hv_pmos ad=1.9p pd=10.38u as=1.9p ps=10.38u w=10u l=0.5u
X26 D54 G53 S53 w_n7898_n1124# sg13_hv_pmos ad=1.9p pd=10.38u as=1.9p ps=10.38u w=10u l=0.5u
X27 S79 G78 D78 w_n7898_n1124# sg13_hv_pmos ad=1.9p pd=10.38u as=1.9p ps=10.38u w=10u l=0.5u
X28 S1 G0 D0 w_n7898_n1124# sg13_hv_pmos ad=1.9p pd=10.38u as=3.4p ps=20.68u w=10u l=0.5u
X29 S3 G2 D2 w_n7898_n1124# sg13_hv_pmos ad=1.9p pd=10.38u as=1.9p ps=10.38u w=10u l=0.5u
X30 D10 G9 S9 w_n7898_n1124# sg13_hv_pmos ad=1.9p pd=10.38u as=1.9p ps=10.38u w=10u l=0.5u
X31 D28 G27 S27 w_n7898_n1124# sg13_hv_pmos ad=1.9p pd=10.38u as=1.9p ps=10.38u w=10u l=0.5u
X32 S61 G60 D60 w_n7898_n1124# sg13_hv_pmos ad=1.9p pd=10.38u as=1.9p ps=10.38u w=10u l=0.5u
X33 D86 G85 S85 w_n7898_n1124# sg13_hv_pmos ad=1.9p pd=10.38u as=1.9p ps=10.38u w=10u l=0.5u
X34 a_7706_n1000# G87 S87 w_n7898_n1124# sg13_hv_pmos ad=3.4p pd=20.68u as=1.9p ps=10.38u w=10u l=0.5u
X35 D16 G15 S15 w_n7898_n1124# sg13_hv_pmos ad=1.9p pd=10.38u as=1.9p ps=10.38u w=10u l=0.5u
X36 S55 G54 D54 w_n7898_n1124# sg13_hv_pmos ad=1.9p pd=10.38u as=1.9p ps=10.38u w=10u l=0.5u
X37 S75 G74 D74 w_n7898_n1124# sg13_hv_pmos ad=1.9p pd=10.38u as=1.9p ps=10.38u w=10u l=0.5u
X38 S7 G6 D6 w_n7898_n1124# sg13_hv_pmos ad=1.9p pd=10.38u as=1.9p ps=10.38u w=10u l=0.5u
X39 S9 G8 D8 w_n7898_n1124# sg13_hv_pmos ad=1.9p pd=10.38u as=1.9p ps=10.38u w=10u l=0.5u
X40 D14 G13 S13 w_n7898_n1124# sg13_hv_pmos ad=1.9p pd=10.38u as=1.9p ps=10.38u w=10u l=0.5u
X41 D34 G33 S33 w_n7898_n1124# sg13_hv_pmos ad=1.9p pd=10.38u as=1.9p ps=10.38u w=10u l=0.5u
X42 S43 G42 D42 w_n7898_n1124# sg13_hv_pmos ad=1.9p pd=10.38u as=1.9p ps=10.38u w=10u l=0.5u
X43 D80 G79 S79 w_n7898_n1124# sg13_hv_pmos ad=1.9p pd=10.38u as=1.9p ps=10.38u w=10u l=0.5u
X44 S87 G86 D86 w_n7898_n1124# sg13_hv_pmos ad=1.9p pd=10.38u as=1.9p ps=10.38u w=10u l=0.5u
X45 D46 G45 S45 w_n7898_n1124# sg13_hv_pmos ad=1.9p pd=10.38u as=1.9p ps=10.38u w=10u l=0.5u
X46 S27 G26 D26 w_n7898_n1124# sg13_hv_pmos ad=1.9p pd=10.38u as=1.9p ps=10.38u w=10u l=0.5u
X47 D74 G73 S73 w_n7898_n1124# sg13_hv_pmos ad=1.9p pd=10.38u as=1.9p ps=10.38u w=10u l=0.5u
X48 D6 G5 S5 w_n7898_n1124# sg13_hv_pmos ad=1.9p pd=10.38u as=1.9p ps=10.38u w=10u l=0.5u
X49 D8 G7 S7 w_n7898_n1124# sg13_hv_pmos ad=1.9p pd=10.38u as=1.9p ps=10.38u w=10u l=0.5u
X50 S15 G14 D14 w_n7898_n1124# sg13_hv_pmos ad=1.9p pd=10.38u as=1.9p ps=10.38u w=10u l=0.5u
X51 D42 G41 S41 w_n7898_n1124# sg13_hv_pmos ad=1.9p pd=10.38u as=1.9p ps=10.38u w=10u l=0.5u
X52 D56 G55 S55 w_n7898_n1124# sg13_hv_pmos ad=1.9p pd=10.38u as=1.9p ps=10.38u w=10u l=0.5u
X53 S81 G80 D80 w_n7898_n1124# sg13_hv_pmos ad=1.9p pd=10.38u as=1.9p ps=10.38u w=10u l=0.5u
X54 S83 G82 D82 w_n7898_n1124# sg13_hv_pmos ad=1.9p pd=10.38u as=1.9p ps=10.38u w=10u l=0.5u
X55 S21 G20 D20 w_n7898_n1124# sg13_hv_pmos ad=1.9p pd=10.38u as=1.9p ps=10.38u w=10u l=0.5u
X56 D26 G25 S25 w_n7898_n1124# sg13_hv_pmos ad=1.9p pd=10.38u as=1.9p ps=10.38u w=10u l=0.5u
X57 S63 G62 D62 w_n7898_n1124# sg13_hv_pmos ad=1.9p pd=10.38u as=1.9p ps=10.38u w=10u l=0.5u
X58 D68 G67 S67 w_n7898_n1124# sg13_hv_pmos ad=1.9p pd=10.38u as=1.9p ps=10.38u w=10u l=0.5u
X59 D70 G69 S69 w_n7898_n1124# sg13_hv_pmos ad=1.9p pd=10.38u as=1.9p ps=10.38u w=10u l=0.5u
X60 D12 G11 S11 w_n7898_n1124# sg13_hv_pmos ad=1.9p pd=10.38u as=1.9p ps=10.38u w=10u l=0.5u
X61 S19 G18 D18 w_n7898_n1124# sg13_hv_pmos ad=1.9p pd=10.38u as=1.9p ps=10.38u w=10u l=0.5u
X62 S41 G40 D40 w_n7898_n1124# sg13_hv_pmos ad=1.9p pd=10.38u as=1.9p ps=10.38u w=10u l=0.5u
X63 D82 G81 S81 w_n7898_n1124# sg13_hv_pmos ad=1.9p pd=10.38u as=1.9p ps=10.38u w=10u l=0.5u
X64 D84 G83 S83 w_n7898_n1124# sg13_hv_pmos ad=1.9p pd=10.38u as=1.9p ps=10.38u w=10u l=0.5u
X65 S39 G38 D38 w_n7898_n1124# sg13_hv_pmos ad=1.9p pd=10.38u as=1.9p ps=10.38u w=10u l=0.5u
X66 D32 G31 S31 w_n7898_n1124# sg13_hv_pmos ad=1.9p pd=10.38u as=1.9p ps=10.38u w=10u l=0.5u
X67 D48 G47 S47 w_n7898_n1124# sg13_hv_pmos ad=1.9p pd=10.38u as=1.9p ps=10.38u w=10u l=0.5u
X68 D50 G49 S49 w_n7898_n1124# sg13_hv_pmos ad=1.9p pd=10.38u as=1.9p ps=10.38u w=10u l=0.5u
X69 D62 G61 S61 w_n7898_n1124# sg13_hv_pmos ad=1.9p pd=10.38u as=1.9p ps=10.38u w=10u l=0.5u
X70 S69 G68 D68 w_n7898_n1124# sg13_hv_pmos ad=1.9p pd=10.38u as=1.9p ps=10.38u w=10u l=0.5u
X71 S11 G10 D10 w_n7898_n1124# sg13_hv_pmos ad=1.9p pd=10.38u as=1.9p ps=10.38u w=10u l=0.5u
X72 S13 G12 D12 w_n7898_n1124# sg13_hv_pmos ad=1.9p pd=10.38u as=1.9p ps=10.38u w=10u l=0.5u
X73 D18 G17 S17 w_n7898_n1124# sg13_hv_pmos ad=1.9p pd=10.38u as=1.9p ps=10.38u w=10u l=0.5u
X74 D20 G19 S19 w_n7898_n1124# sg13_hv_pmos ad=1.9p pd=10.38u as=1.9p ps=10.38u w=10u l=0.5u
X75 D40 G39 S39 w_n7898_n1124# sg13_hv_pmos ad=1.9p pd=10.38u as=1.9p ps=10.38u w=10u l=0.5u
X76 S71 G70 D70 w_n7898_n1124# sg13_hv_pmos ad=1.9p pd=10.38u as=1.9p ps=10.38u w=10u l=0.5u
X77 D76 G75 S75 w_n7898_n1124# sg13_hv_pmos ad=1.9p pd=10.38u as=1.9p ps=10.38u w=10u l=0.5u
X78 D78 G77 S77 w_n7898_n1124# sg13_hv_pmos ad=1.9p pd=10.38u as=1.9p ps=10.38u w=10u l=0.5u
X79 S31 G30 D30 w_n7898_n1124# sg13_hv_pmos ad=1.9p pd=10.38u as=1.9p ps=10.38u w=10u l=0.5u
X80 S33 G32 D32 w_n7898_n1124# sg13_hv_pmos ad=1.9p pd=10.38u as=1.9p ps=10.38u w=10u l=0.5u
X81 S47 G46 D46 w_n7898_n1124# sg13_hv_pmos ad=1.9p pd=10.38u as=1.9p ps=10.38u w=10u l=0.5u
X82 S49 G48 D48 w_n7898_n1124# sg13_hv_pmos ad=1.9p pd=10.38u as=1.9p ps=10.38u w=10u l=0.5u
X83 D58 G57 S57 w_n7898_n1124# sg13_hv_pmos ad=1.9p pd=10.38u as=1.9p ps=10.38u w=10u l=0.5u
X84 S65 G64 D64 w_n7898_n1124# sg13_hv_pmos ad=1.9p pd=10.38u as=1.9p ps=10.38u w=10u l=0.5u
X85 S17 G16 D16 w_n7898_n1124# sg13_hv_pmos ad=1.9p pd=10.38u as=1.9p ps=10.38u w=10u l=0.5u
X86 D24 G23 S23 w_n7898_n1124# sg13_hv_pmos ad=1.9p pd=10.38u as=1.9p ps=10.38u w=10u l=0.5u
X87 S77 G76 D76 w_n7898_n1124# sg13_hv_pmos ad=1.9p pd=10.38u as=1.9p ps=10.38u w=10u l=0.5u
.ends

.subckt gate_drive in_p in_n vss vdd out
Xsg13_hv_nmos_XAVYYR_0 vss in_p sg13_hv_pmos_YZSTZS_0/S1 in_p vss in_n sg13_hv_pmos_YZSTZS_0/S3
+ in_n vss vss sg13_hv_nmos_XAVYYR
Xsg13_hv_nmos_3JX36Y_0 vss sg13_hv_pmos_YZSTZS_0/S3 sg13_hv_pmos_RQMCRC_0/S1 sg13_hv_pmos_YZSTZS_0/S3
+ vss sg13_hv_pmos_RQMCRC_0/S1 sg13_hv_pmos_RQMCRC_0/S7 sg13_hv_pmos_RQMCRC_0/S1 vss
+ sg13_hv_pmos_RQMCRC_0/S1 sg13_hv_pmos_RQMCRC_0/S7 sg13_hv_pmos_RQMCRC_0/S1 vss sg13_hv_pmos_RQMCRC_0/S1
+ sg13_hv_pmos_RQMCRC_0/S7 sg13_hv_pmos_RQMCRC_0/S1 vss sg13_hv_pmos_RQMCRC_0/S7 sg13_hv_pmos_RQMCRC_0/S9
+ sg13_hv_pmos_RQMCRC_0/S7 vss sg13_hv_pmos_RQMCRC_0/S7 sg13_hv_pmos_RQMCRC_0/S9 sg13_hv_pmos_RQMCRC_0/S7
+ vss sg13_hv_pmos_RQMCRC_0/S7 sg13_hv_pmos_RQMCRC_0/S9 sg13_hv_pmos_RQMCRC_0/S7 vss
+ sg13_hv_pmos_RQMCRC_0/S7 sg13_hv_pmos_RQMCRC_0/S9 sg13_hv_pmos_RQMCRC_0/S7 vss sg13_hv_pmos_RQMCRC_0/S7
+ sg13_hv_pmos_RQMCRC_0/S9 sg13_hv_pmos_RQMCRC_0/S7 vss sg13_hv_pmos_RQMCRC_0/S7 sg13_hv_pmos_RQMCRC_0/S9
+ sg13_hv_pmos_RQMCRC_0/S7 vss sg13_hv_pmos_RQMCRC_0/S7 sg13_hv_pmos_RQMCRC_0/S9 sg13_hv_pmos_RQMCRC_0/S7
+ vss sg13_hv_pmos_RQMCRC_0/S7 sg13_hv_pmos_RQMCRC_0/S9 sg13_hv_pmos_RQMCRC_0/S7 vss
+ sg13_hv_pmos_RQMCRC_0/S7 sg13_hv_pmos_RQMCRC_0/S9 sg13_hv_pmos_RQMCRC_0/S7 vss sg13_hv_pmos_RQMCRC_0/S7
+ sg13_hv_pmos_RQMCRC_0/S9 sg13_hv_pmos_RQMCRC_0/S7 vss sg13_hv_pmos_RQMCRC_0/S9 out
+ sg13_hv_pmos_RQMCRC_0/S9 vss sg13_hv_pmos_RQMCRC_0/S9 out sg13_hv_pmos_RQMCRC_0/S9
+ vss sg13_hv_pmos_RQMCRC_0/S9 out sg13_hv_pmos_RQMCRC_0/S9 vss sg13_hv_pmos_RQMCRC_0/S9
+ out sg13_hv_pmos_RQMCRC_0/S9 vss sg13_hv_pmos_RQMCRC_0/S9 out sg13_hv_pmos_RQMCRC_0/S9
+ vss sg13_hv_pmos_RQMCRC_0/S9 out sg13_hv_pmos_RQMCRC_0/S9 vss sg13_hv_pmos_RQMCRC_0/S9
+ out sg13_hv_pmos_RQMCRC_0/S9 vss sg13_hv_pmos_RQMCRC_0/S9 out sg13_hv_pmos_RQMCRC_0/S9
+ vss sg13_hv_pmos_RQMCRC_0/S9 out sg13_hv_pmos_RQMCRC_0/S9 vss sg13_hv_pmos_RQMCRC_0/S9
+ out sg13_hv_pmos_RQMCRC_0/S9 vss sg13_hv_pmos_RQMCRC_0/S9 out sg13_hv_pmos_RQMCRC_0/S9
+ vss sg13_hv_pmos_RQMCRC_0/S9 out sg13_hv_pmos_RQMCRC_0/S9 vss sg13_hv_pmos_RQMCRC_0/S9
+ out sg13_hv_pmos_RQMCRC_0/S9 vss sg13_hv_pmos_RQMCRC_0/S9 out sg13_hv_pmos_RQMCRC_0/S9
+ vss sg13_hv_pmos_RQMCRC_0/S9 out sg13_hv_pmos_RQMCRC_0/S9 vss sg13_hv_pmos_RQMCRC_0/S9
+ out sg13_hv_pmos_RQMCRC_0/S9 vss sg13_hv_pmos_RQMCRC_0/S9 out sg13_hv_pmos_RQMCRC_0/S9
+ vss sg13_hv_pmos_RQMCRC_0/S9 out sg13_hv_pmos_RQMCRC_0/S9 vss sg13_hv_pmos_RQMCRC_0/S9
+ out sg13_hv_pmos_RQMCRC_0/S9 vss sg13_hv_pmos_RQMCRC_0/S9 out sg13_hv_pmos_RQMCRC_0/S9
+ vss sg13_hv_pmos_RQMCRC_0/S9 out sg13_hv_pmos_RQMCRC_0/S9 vss sg13_hv_pmos_RQMCRC_0/S9
+ out sg13_hv_pmos_RQMCRC_0/S9 vss sg13_hv_pmos_RQMCRC_0/S9 out sg13_hv_pmos_RQMCRC_0/S9
+ vss sg13_hv_pmos_RQMCRC_0/S9 out sg13_hv_pmos_RQMCRC_0/S9 vss sg13_hv_pmos_RQMCRC_0/S9
+ out sg13_hv_pmos_RQMCRC_0/S9 vss sg13_hv_pmos_RQMCRC_0/S9 out sg13_hv_pmos_RQMCRC_0/S9
+ vss sg13_hv_pmos_RQMCRC_0/S9 out sg13_hv_pmos_RQMCRC_0/S9 vss sg13_hv_pmos_RQMCRC_0/S9
+ out sg13_hv_pmos_RQMCRC_0/S9 vss sg13_hv_pmos_RQMCRC_0/S9 out sg13_hv_pmos_RQMCRC_0/S9
+ vss sg13_hv_pmos_RQMCRC_0/S9 out sg13_hv_pmos_RQMCRC_0/S9 vss vss sg13_hv_nmos_3JX36Y
Xsg13_hv_pmos_YZSTZS_0 vdd sg13_hv_pmos_YZSTZS_0/S3 sg13_hv_pmos_YZSTZS_0/S1 sg13_hv_pmos_YZSTZS_0/S3
+ vdd sg13_hv_pmos_YZSTZS_0/S1 sg13_hv_pmos_YZSTZS_0/S3 sg13_hv_pmos_YZSTZS_0/S1 vdd
+ vdd sg13_hv_pmos_YZSTZS
Xsg13_hv_pmos_RQMCRC_0 vdd sg13_hv_pmos_YZSTZS_0/S3 sg13_hv_pmos_RQMCRC_0/S1 sg13_hv_pmos_YZSTZS_0/S3
+ vdd sg13_hv_pmos_RQMCRC_0/S1 sg13_hv_pmos_RQMCRC_0/S7 sg13_hv_pmos_RQMCRC_0/S1 vdd
+ sg13_hv_pmos_RQMCRC_0/S1 sg13_hv_pmos_RQMCRC_0/S7 sg13_hv_pmos_RQMCRC_0/S1 vdd sg13_hv_pmos_RQMCRC_0/S1
+ sg13_hv_pmos_RQMCRC_0/S7 sg13_hv_pmos_RQMCRC_0/S1 vdd sg13_hv_pmos_RQMCRC_0/S7 sg13_hv_pmos_RQMCRC_0/S9
+ sg13_hv_pmos_RQMCRC_0/S7 vdd sg13_hv_pmos_RQMCRC_0/S7 sg13_hv_pmos_RQMCRC_0/S9 sg13_hv_pmos_RQMCRC_0/S7
+ vdd sg13_hv_pmos_RQMCRC_0/S7 sg13_hv_pmos_RQMCRC_0/S9 sg13_hv_pmos_RQMCRC_0/S7 vdd
+ sg13_hv_pmos_RQMCRC_0/S7 sg13_hv_pmos_RQMCRC_0/S9 sg13_hv_pmos_RQMCRC_0/S7 vdd sg13_hv_pmos_RQMCRC_0/S7
+ sg13_hv_pmos_RQMCRC_0/S9 sg13_hv_pmos_RQMCRC_0/S7 vdd sg13_hv_pmos_RQMCRC_0/S7 sg13_hv_pmos_RQMCRC_0/S9
+ sg13_hv_pmos_RQMCRC_0/S7 vdd sg13_hv_pmos_RQMCRC_0/S7 sg13_hv_pmos_RQMCRC_0/S9 sg13_hv_pmos_RQMCRC_0/S7
+ vdd sg13_hv_pmos_RQMCRC_0/S7 sg13_hv_pmos_RQMCRC_0/S9 sg13_hv_pmos_RQMCRC_0/S7 vdd
+ sg13_hv_pmos_RQMCRC_0/S7 sg13_hv_pmos_RQMCRC_0/S9 sg13_hv_pmos_RQMCRC_0/S7 vdd sg13_hv_pmos_RQMCRC_0/S7
+ sg13_hv_pmos_RQMCRC_0/S9 sg13_hv_pmos_RQMCRC_0/S7 vdd sg13_hv_pmos_RQMCRC_0/S9 out
+ sg13_hv_pmos_RQMCRC_0/S9 vdd sg13_hv_pmos_RQMCRC_0/S9 out sg13_hv_pmos_RQMCRC_0/S9
+ vdd sg13_hv_pmos_RQMCRC_0/S9 out sg13_hv_pmos_RQMCRC_0/S9 vdd sg13_hv_pmos_RQMCRC_0/S9
+ out sg13_hv_pmos_RQMCRC_0/S9 vdd sg13_hv_pmos_RQMCRC_0/S9 out sg13_hv_pmos_RQMCRC_0/S9
+ vdd sg13_hv_pmos_RQMCRC_0/S9 out sg13_hv_pmos_RQMCRC_0/S9 vdd sg13_hv_pmos_RQMCRC_0/S9
+ out sg13_hv_pmos_RQMCRC_0/S9 vdd sg13_hv_pmos_RQMCRC_0/S9 out sg13_hv_pmos_RQMCRC_0/S9
+ vdd sg13_hv_pmos_RQMCRC_0/S9 out sg13_hv_pmos_RQMCRC_0/S9 vdd sg13_hv_pmos_RQMCRC_0/S9
+ out sg13_hv_pmos_RQMCRC_0/S9 vdd sg13_hv_pmos_RQMCRC_0/S9 out sg13_hv_pmos_RQMCRC_0/S9
+ vdd sg13_hv_pmos_RQMCRC_0/S9 out sg13_hv_pmos_RQMCRC_0/S9 vdd sg13_hv_pmos_RQMCRC_0/S9
+ out sg13_hv_pmos_RQMCRC_0/S9 vdd sg13_hv_pmos_RQMCRC_0/S9 out sg13_hv_pmos_RQMCRC_0/S9
+ vdd sg13_hv_pmos_RQMCRC_0/S9 out sg13_hv_pmos_RQMCRC_0/S9 vdd sg13_hv_pmos_RQMCRC_0/S9
+ out sg13_hv_pmos_RQMCRC_0/S9 vdd sg13_hv_pmos_RQMCRC_0/S9 out sg13_hv_pmos_RQMCRC_0/S9
+ vdd sg13_hv_pmos_RQMCRC_0/S9 out sg13_hv_pmos_RQMCRC_0/S9 vdd sg13_hv_pmos_RQMCRC_0/S9
+ out sg13_hv_pmos_RQMCRC_0/S9 vdd sg13_hv_pmos_RQMCRC_0/S9 out sg13_hv_pmos_RQMCRC_0/S9
+ vdd sg13_hv_pmos_RQMCRC_0/S9 out sg13_hv_pmos_RQMCRC_0/S9 vdd sg13_hv_pmos_RQMCRC_0/S9
+ out sg13_hv_pmos_RQMCRC_0/S9 vdd sg13_hv_pmos_RQMCRC_0/S9 out sg13_hv_pmos_RQMCRC_0/S9
+ vdd sg13_hv_pmos_RQMCRC_0/S9 out sg13_hv_pmos_RQMCRC_0/S9 vdd sg13_hv_pmos_RQMCRC_0/S9
+ out sg13_hv_pmos_RQMCRC_0/S9 vdd sg13_hv_pmos_RQMCRC_0/S9 out sg13_hv_pmos_RQMCRC_0/S9
+ vdd sg13_hv_pmos_RQMCRC_0/S9 out sg13_hv_pmos_RQMCRC_0/S9 vdd sg13_hv_pmos_RQMCRC_0/S9
+ out sg13_hv_pmos_RQMCRC_0/S9 vdd sg13_hv_pmos_RQMCRC_0/S9 out sg13_hv_pmos_RQMCRC_0/S9
+ vdd sg13_hv_pmos_RQMCRC_0/S9 out sg13_hv_pmos_RQMCRC_0/S9 vdd vdd sg13_hv_pmos_RQMCRC
.ends

.subckt sg13cmos5l_antennanp A VDD VSS
X0 A VDD dpantenna l=1.34u w=1.05u
X1 VSS A dantenna l=0.78u w=0.78u
.ends

.subckt sg13cmos5l_decap_4 VDD VSS
X0 VDD VSS VDD VDD sg13_lv_pmos ad=0.34p pd=2.68u as=2.4331p ps=11.58u w=1u l=1u
X1 VSS VDD VSS VSS sg13_lv_nmos ad=0.1428p pd=1.52u as=1.84612p ps=9.32u w=0.42u l=1u
.ends

.subckt sg13cmos5l_inv_4 Y A VDD VSS
X0 Y A VSS VSS sg13_lv_nmos ad=0.1406p pd=1.12u as=0.2516p ps=2.16u w=0.74u l=0.13u
X1 Y A VDD VDD sg13_lv_pmos ad=0.2128p pd=1.5u as=0.3808p ps=2.92u w=1.12u l=0.13u
X2 VSS A Y VSS sg13_lv_nmos ad=0.1406p pd=1.12u as=0.1406p ps=1.12u w=0.74u l=0.13u
X3 Y A VSS VSS sg13_lv_nmos ad=0.1406p pd=1.12u as=0.1406p ps=1.12u w=0.74u l=0.13u
X4 VDD A Y VDD sg13_lv_pmos ad=0.2128p pd=1.5u as=0.2128p ps=1.5u w=1.12u l=0.13u
X5 VSS A Y VSS sg13_lv_nmos ad=0.2516p pd=2.16u as=0.1406p ps=1.12u w=0.74u l=0.13u
X6 Y A VDD VDD sg13_lv_pmos ad=0.2128p pd=1.5u as=0.2128p ps=1.5u w=1.12u l=0.13u
X7 VDD A Y VDD sg13_lv_pmos ad=0.3808p pd=2.92u as=0.2128p ps=1.5u w=1.12u l=0.13u
.ends

.subckt power_stage2 IOVDD_IN IOVDD_OUT DVDD DVSS IOVSS enable
Xsg13_hv_pmos_ZN7EJW_2 IOVDD_IN IOVDD_IN gate_drive_0/out IOVDD_IN IOVDD_IN IOVDD_IN
+ IOVDD_IN IOVDD_IN IOVDD_IN IOVDD_IN IOVDD_IN IOVDD_IN IOVDD_OUT IOVDD_OUT IOVDD_OUT
+ IOVDD_OUT IOVDD_OUT IOVDD_OUT IOVDD_OUT IOVDD_OUT IOVDD_OUT IOVDD_OUT IOVDD_IN IOVDD_IN
+ IOVDD_IN IOVDD_IN IOVDD_IN IOVDD_IN IOVDD_IN IOVDD_IN IOVDD_IN IOVDD_IN IOVDD_OUT
+ IOVDD_OUT IOVDD_OUT IOVDD_OUT IOVDD_OUT IOVDD_OUT IOVDD_OUT IOVDD_OUT IOVDD_OUT
+ IOVDD_OUT IOVDD_IN IOVDD_IN IOVDD_IN IOVDD_IN IOVDD_IN IOVDD_IN IOVDD_IN IOVDD_IN
+ IOVDD_IN IOVDD_IN IOVDD_OUT IOVDD_OUT IOVDD_OUT IOVDD_OUT IOVDD_OUT IOVDD_OUT IOVDD_OUT
+ IOVDD_OUT IOVDD_OUT IOVDD_OUT IOVDD_IN IOVDD_IN IOVDD_IN IOVDD_IN IOVDD_IN IOVDD_IN
+ IOVDD_IN IOVDD_IN IOVDD_IN IOVDD_IN IOVDD_OUT IOVDD_OUT IOVDD_OUT IOVDD_OUT IOVDD_OUT
+ IOVDD_OUT IOVDD_OUT IOVDD_OUT IOVDD_OUT IOVDD_OUT IOVDD_IN IOVDD_IN IOVDD_IN IOVDD_IN
+ IOVDD_IN IOVDD_IN IOVDD_IN IOVDD_IN IOVDD_IN IOVDD_IN IOVDD_OUT IOVDD_OUT IOVDD_OUT
+ IOVDD_OUT IOVDD_OUT IOVDD_OUT IOVDD_OUT IOVDD_OUT IOVDD_OUT IOVDD_OUT IOVDD_IN IOVDD_IN
+ IOVDD_IN IOVDD_IN IOVDD_IN IOVDD_IN IOVDD_IN IOVDD_IN IOVDD_IN IOVDD_IN sg13_hv_pmos_ZN7EJW
Xsg13_hv_pmos_ZN7EJW_3 IOVDD_IN IOVDD_IN gate_drive_0/out IOVDD_IN IOVDD_IN IOVDD_IN
+ IOVDD_IN IOVDD_IN IOVDD_IN IOVDD_IN IOVDD_IN IOVDD_IN IOVDD_OUT IOVDD_OUT IOVDD_OUT
+ IOVDD_OUT IOVDD_OUT IOVDD_OUT IOVDD_OUT IOVDD_OUT IOVDD_OUT IOVDD_OUT IOVDD_IN IOVDD_IN
+ IOVDD_IN IOVDD_IN IOVDD_IN IOVDD_IN IOVDD_IN IOVDD_IN IOVDD_IN IOVDD_IN IOVDD_OUT
+ IOVDD_OUT IOVDD_OUT IOVDD_OUT IOVDD_OUT IOVDD_OUT IOVDD_OUT IOVDD_OUT IOVDD_OUT
+ IOVDD_OUT IOVDD_IN IOVDD_IN IOVDD_IN IOVDD_IN IOVDD_IN IOVDD_IN IOVDD_IN IOVDD_IN
+ IOVDD_IN IOVDD_IN IOVDD_OUT IOVDD_OUT IOVDD_OUT IOVDD_OUT IOVDD_OUT IOVDD_OUT IOVDD_OUT
+ IOVDD_OUT IOVDD_OUT IOVDD_OUT IOVDD_IN IOVDD_IN IOVDD_IN IOVDD_IN IOVDD_IN IOVDD_IN
+ IOVDD_IN IOVDD_IN IOVDD_IN IOVDD_IN IOVDD_OUT IOVDD_OUT IOVDD_OUT IOVDD_OUT IOVDD_OUT
+ IOVDD_OUT IOVDD_OUT IOVDD_OUT IOVDD_OUT IOVDD_OUT IOVDD_IN IOVDD_IN IOVDD_IN IOVDD_IN
+ IOVDD_IN IOVDD_IN IOVDD_IN IOVDD_IN IOVDD_IN IOVDD_IN IOVDD_OUT IOVDD_OUT IOVDD_OUT
+ IOVDD_OUT IOVDD_OUT IOVDD_OUT IOVDD_OUT IOVDD_OUT IOVDD_OUT IOVDD_OUT IOVDD_IN IOVDD_IN
+ IOVDD_IN IOVDD_IN IOVDD_IN IOVDD_IN IOVDD_IN IOVDD_IN IOVDD_IN IOVDD_IN sg13_hv_pmos_ZN7EJW
Xsg13_hv_pmos_ZN7EJW_4 IOVDD_IN IOVDD_IN gate_drive_0/out IOVDD_IN IOVDD_IN IOVDD_IN
+ IOVDD_IN IOVDD_IN IOVDD_IN IOVDD_IN IOVDD_IN IOVDD_IN IOVDD_OUT IOVDD_OUT IOVDD_OUT
+ IOVDD_OUT IOVDD_OUT IOVDD_OUT IOVDD_OUT IOVDD_OUT IOVDD_OUT IOVDD_OUT IOVDD_IN IOVDD_IN
+ IOVDD_IN IOVDD_IN IOVDD_IN IOVDD_IN IOVDD_IN IOVDD_IN IOVDD_IN IOVDD_IN IOVDD_OUT
+ IOVDD_OUT IOVDD_OUT IOVDD_OUT IOVDD_OUT IOVDD_OUT IOVDD_OUT IOVDD_OUT IOVDD_OUT
+ IOVDD_OUT IOVDD_IN IOVDD_IN IOVDD_IN IOVDD_IN IOVDD_IN IOVDD_IN IOVDD_IN IOVDD_IN
+ IOVDD_IN IOVDD_IN IOVDD_OUT IOVDD_OUT IOVDD_OUT IOVDD_OUT IOVDD_OUT IOVDD_OUT IOVDD_OUT
+ IOVDD_OUT IOVDD_OUT IOVDD_OUT IOVDD_IN IOVDD_IN IOVDD_IN IOVDD_IN IOVDD_IN IOVDD_IN
+ IOVDD_IN IOVDD_IN IOVDD_IN IOVDD_IN IOVDD_OUT IOVDD_OUT IOVDD_OUT IOVDD_OUT IOVDD_OUT
+ IOVDD_OUT IOVDD_OUT IOVDD_OUT IOVDD_OUT IOVDD_OUT IOVDD_IN IOVDD_IN IOVDD_IN IOVDD_IN
+ IOVDD_IN IOVDD_IN IOVDD_IN IOVDD_IN IOVDD_IN IOVDD_IN IOVDD_OUT IOVDD_OUT IOVDD_OUT
+ IOVDD_OUT IOVDD_OUT IOVDD_OUT IOVDD_OUT IOVDD_OUT IOVDD_OUT IOVDD_OUT IOVDD_IN IOVDD_IN
+ IOVDD_IN IOVDD_IN IOVDD_IN IOVDD_IN IOVDD_IN IOVDD_IN IOVDD_IN IOVDD_IN sg13_hv_pmos_ZN7EJW
Xsg13_hv_pmos_ZN7EJW_5 IOVDD_IN IOVDD_IN gate_drive_0/out IOVDD_IN IOVDD_IN IOVDD_IN
+ IOVDD_IN IOVDD_IN IOVDD_IN IOVDD_IN IOVDD_IN IOVDD_IN IOVDD_OUT IOVDD_OUT IOVDD_OUT
+ IOVDD_OUT IOVDD_OUT IOVDD_OUT IOVDD_OUT IOVDD_OUT IOVDD_OUT IOVDD_OUT IOVDD_IN IOVDD_IN
+ IOVDD_IN IOVDD_IN IOVDD_IN IOVDD_IN IOVDD_IN IOVDD_IN IOVDD_IN IOVDD_IN IOVDD_OUT
+ IOVDD_OUT IOVDD_OUT IOVDD_OUT IOVDD_OUT IOVDD_OUT IOVDD_OUT IOVDD_OUT IOVDD_OUT
+ IOVDD_OUT IOVDD_IN IOVDD_IN IOVDD_IN IOVDD_IN IOVDD_IN IOVDD_IN IOVDD_IN IOVDD_IN
+ IOVDD_IN IOVDD_IN IOVDD_OUT IOVDD_OUT IOVDD_OUT IOVDD_OUT IOVDD_OUT IOVDD_OUT IOVDD_OUT
+ IOVDD_OUT IOVDD_OUT IOVDD_OUT IOVDD_IN IOVDD_IN IOVDD_IN IOVDD_IN IOVDD_IN IOVDD_IN
+ IOVDD_IN IOVDD_IN IOVDD_IN IOVDD_IN IOVDD_OUT IOVDD_OUT IOVDD_OUT IOVDD_OUT IOVDD_OUT
+ IOVDD_OUT IOVDD_OUT IOVDD_OUT IOVDD_OUT IOVDD_OUT IOVDD_IN IOVDD_IN IOVDD_IN IOVDD_IN
+ IOVDD_IN IOVDD_IN IOVDD_IN IOVDD_IN IOVDD_IN IOVDD_IN IOVDD_OUT IOVDD_OUT IOVDD_OUT
+ IOVDD_OUT IOVDD_OUT IOVDD_OUT IOVDD_OUT IOVDD_OUT IOVDD_OUT IOVDD_OUT IOVDD_IN IOVDD_IN
+ IOVDD_IN IOVDD_IN IOVDD_IN IOVDD_IN IOVDD_IN IOVDD_IN IOVDD_IN IOVDD_IN sg13_hv_pmos_ZN7EJW
Xsg13_hv_pmos_ZN7EJW_6 IOVDD_IN IOVDD_IN gate_drive_0/out IOVDD_IN IOVDD_IN IOVDD_IN
+ IOVDD_IN IOVDD_IN IOVDD_IN IOVDD_IN IOVDD_IN IOVDD_IN IOVDD_OUT IOVDD_OUT IOVDD_OUT
+ IOVDD_OUT IOVDD_OUT IOVDD_OUT IOVDD_OUT IOVDD_OUT IOVDD_OUT IOVDD_OUT IOVDD_IN IOVDD_IN
+ IOVDD_IN IOVDD_IN IOVDD_IN IOVDD_IN IOVDD_IN IOVDD_IN IOVDD_IN IOVDD_IN IOVDD_OUT
+ IOVDD_OUT IOVDD_OUT IOVDD_OUT IOVDD_OUT IOVDD_OUT IOVDD_OUT IOVDD_OUT IOVDD_OUT
+ IOVDD_OUT IOVDD_IN IOVDD_IN IOVDD_IN IOVDD_IN IOVDD_IN IOVDD_IN IOVDD_IN IOVDD_IN
+ IOVDD_IN IOVDD_IN IOVDD_OUT IOVDD_OUT IOVDD_OUT IOVDD_OUT IOVDD_OUT IOVDD_OUT IOVDD_OUT
+ IOVDD_OUT IOVDD_OUT IOVDD_OUT IOVDD_IN IOVDD_IN IOVDD_IN IOVDD_IN IOVDD_IN IOVDD_IN
+ IOVDD_IN IOVDD_IN IOVDD_IN IOVDD_IN IOVDD_OUT IOVDD_OUT IOVDD_OUT IOVDD_OUT IOVDD_OUT
+ IOVDD_OUT IOVDD_OUT IOVDD_OUT IOVDD_OUT IOVDD_OUT IOVDD_IN IOVDD_IN IOVDD_IN IOVDD_IN
+ IOVDD_IN IOVDD_IN IOVDD_IN IOVDD_IN IOVDD_IN IOVDD_IN IOVDD_OUT IOVDD_OUT IOVDD_OUT
+ IOVDD_OUT IOVDD_OUT IOVDD_OUT IOVDD_OUT IOVDD_OUT IOVDD_OUT IOVDD_OUT IOVDD_IN IOVDD_IN
+ IOVDD_IN IOVDD_IN IOVDD_IN IOVDD_IN IOVDD_IN IOVDD_IN IOVDD_IN IOVDD_IN sg13_hv_pmos_ZN7EJW
Xgate_drive_0 gate_drive_0/in_p gate_drive_0/in_n IOVSS IOVDD_IN gate_drive_0/out
+ gate_drive
Xsg13cmos5l_antennanp_0 enable DVDD DVSS sg13cmos5l_antennanp
Xsg13cmos5l_decap_4_0 DVDD DVSS sg13cmos5l_decap_4
Xsg13cmos5l_decap_4_1 DVDD DVSS sg13cmos5l_decap_4
Xsg13cmos5l_inv_4_0 gate_drive_0/in_p enable DVDD DVSS sg13cmos5l_inv_4
Xsg13_hv_pmos_ZN7EJW_0 IOVDD_IN IOVDD_IN gate_drive_0/out IOVDD_IN IOVDD_IN IOVDD_IN
+ IOVDD_IN IOVDD_IN IOVDD_IN IOVDD_IN IOVDD_IN IOVDD_IN IOVDD_OUT IOVDD_OUT IOVDD_OUT
+ IOVDD_OUT IOVDD_OUT IOVDD_OUT IOVDD_OUT IOVDD_OUT IOVDD_OUT IOVDD_OUT IOVDD_IN IOVDD_IN
+ IOVDD_IN IOVDD_IN IOVDD_IN IOVDD_IN IOVDD_IN IOVDD_IN IOVDD_IN IOVDD_IN IOVDD_OUT
+ IOVDD_OUT IOVDD_OUT IOVDD_OUT IOVDD_OUT IOVDD_OUT IOVDD_OUT IOVDD_OUT IOVDD_OUT
+ IOVDD_OUT IOVDD_IN IOVDD_IN IOVDD_IN IOVDD_IN IOVDD_IN IOVDD_IN IOVDD_IN IOVDD_IN
+ IOVDD_IN IOVDD_IN IOVDD_OUT IOVDD_OUT IOVDD_OUT IOVDD_OUT IOVDD_OUT IOVDD_OUT IOVDD_OUT
+ IOVDD_OUT IOVDD_OUT IOVDD_OUT IOVDD_IN IOVDD_IN IOVDD_IN IOVDD_IN IOVDD_IN IOVDD_IN
+ IOVDD_IN IOVDD_IN IOVDD_IN IOVDD_IN IOVDD_OUT IOVDD_OUT IOVDD_OUT IOVDD_OUT IOVDD_OUT
+ IOVDD_OUT IOVDD_OUT IOVDD_OUT IOVDD_OUT IOVDD_OUT IOVDD_IN IOVDD_IN IOVDD_IN IOVDD_IN
+ IOVDD_IN IOVDD_IN IOVDD_IN IOVDD_IN IOVDD_IN IOVDD_IN IOVDD_OUT IOVDD_OUT IOVDD_OUT
+ IOVDD_OUT IOVDD_OUT IOVDD_OUT IOVDD_OUT IOVDD_OUT IOVDD_OUT IOVDD_OUT IOVDD_IN IOVDD_IN
+ IOVDD_IN IOVDD_IN IOVDD_IN IOVDD_IN IOVDD_IN IOVDD_IN IOVDD_IN IOVDD_IN sg13_hv_pmos_ZN7EJW
Xsg13cmos5l_inv_4_1 gate_drive_0/in_n gate_drive_0/in_p DVDD DVSS sg13cmos5l_inv_4
Xsg13_hv_pmos_ZN7EJW_1 IOVDD_IN IOVDD_IN gate_drive_0/out IOVDD_IN IOVDD_IN IOVDD_IN
+ IOVDD_IN IOVDD_IN IOVDD_IN IOVDD_IN IOVDD_IN IOVDD_IN IOVDD_OUT IOVDD_OUT IOVDD_OUT
+ IOVDD_OUT IOVDD_OUT IOVDD_OUT IOVDD_OUT IOVDD_OUT IOVDD_OUT IOVDD_OUT IOVDD_IN IOVDD_IN
+ IOVDD_IN IOVDD_IN IOVDD_IN IOVDD_IN IOVDD_IN IOVDD_IN IOVDD_IN IOVDD_IN IOVDD_OUT
+ IOVDD_OUT IOVDD_OUT IOVDD_OUT IOVDD_OUT IOVDD_OUT IOVDD_OUT IOVDD_OUT IOVDD_OUT
+ IOVDD_OUT IOVDD_IN IOVDD_IN IOVDD_IN IOVDD_IN IOVDD_IN IOVDD_IN IOVDD_IN IOVDD_IN
+ IOVDD_IN IOVDD_IN IOVDD_OUT IOVDD_OUT IOVDD_OUT IOVDD_OUT IOVDD_OUT IOVDD_OUT IOVDD_OUT
+ IOVDD_OUT IOVDD_OUT IOVDD_OUT IOVDD_IN IOVDD_IN IOVDD_IN IOVDD_IN IOVDD_IN IOVDD_IN
+ IOVDD_IN IOVDD_IN IOVDD_IN IOVDD_IN IOVDD_OUT IOVDD_OUT IOVDD_OUT IOVDD_OUT IOVDD_OUT
+ IOVDD_OUT IOVDD_OUT IOVDD_OUT IOVDD_OUT IOVDD_OUT IOVDD_IN IOVDD_IN IOVDD_IN IOVDD_IN
+ IOVDD_IN IOVDD_IN IOVDD_IN IOVDD_IN IOVDD_IN IOVDD_IN IOVDD_OUT IOVDD_OUT IOVDD_OUT
+ IOVDD_OUT IOVDD_OUT IOVDD_OUT IOVDD_OUT IOVDD_OUT IOVDD_OUT IOVDD_OUT IOVDD_IN IOVDD_IN
+ IOVDD_IN IOVDD_IN IOVDD_IN IOVDD_IN IOVDD_IN IOVDD_IN IOVDD_IN IOVDD_IN sg13_hv_pmos_ZN7EJW
.ends
