* NGSPICE file created from analog_pswitch_small.ext - technology: ihp-sg13cmos5l

.subckt sg13cmos5l_antennanp A VDD VSS
X0 A VDD dpantenna l=1.34u w=1.05u
X1 VSS A dantenna l=0.78u w=0.78u
.ends

.subckt sg13_hv_pmos_HVFXC8 B D0 G S1 D2 S3 a_376_n500#
X0 a_376_n500# G S3 B sg13_hv_pmos ad=3.4p pd=11.36u as=1.8p ps=5.72u w=5u l=0.4u
X1 S1 G D0 B sg13_hv_pmos ad=1.8p pd=5.72u as=3.4p ps=11.36u w=5u l=0.4u
X2 D2 G S1 B sg13_hv_pmos ad=1.8p pd=5.72u as=1.8p ps=5.72u w=5u l=0.4u
X3 S3 G D2 B sg13_hv_pmos ad=1.8p pd=5.72u as=1.8p ps=5.72u w=5u l=0.4u
.ends

.subckt sg13_hv_pmos_XRP95E D0 G0 S1 G1 D2 G2 S3 G3 w_n506_n324# a_314_n200#
X0 S3 G2 D2 w_n506_n324# sg13_hv_pmos ad=0.38p pd=2.38u as=0.38p ps=2.38u w=2u l=0.5u
X1 D2 G1 S1 w_n506_n324# sg13_hv_pmos ad=0.38p pd=2.38u as=0.38p ps=2.38u w=2u l=0.5u
X2 S1 G0 D0 w_n506_n324# sg13_hv_pmos ad=0.38p pd=2.38u as=0.68p ps=4.68u w=2u l=0.5u
X3 a_314_n200# G3 S3 w_n506_n324# sg13_hv_pmos ad=0.68p pd=4.68u as=0.38p ps=2.38u w=2u l=0.5u
.ends

.subckt sg13_hv_pmos_2TUKLB D0 G0 S1 G1 w_n330_n174# a_138_n50#
X0 a_138_n50# G1 S1 w_n330_n174# sg13_hv_pmos ad=0.17p pd=1.68u as=95f ps=0.88u w=0.5u l=0.5u
X1 S1 G0 D0 w_n330_n174# sg13_hv_pmos ad=95f pd=0.88u as=0.17p ps=1.68u w=0.5u l=0.5u
.ends

.subckt sg13_hv_nmos_CJ33WB D0 S0 G0 D1 S1 G1 sub
X0 D1 G1 S1 sub sg13_hv_nmos ad=0.68p pd=4.68u as=0.68p ps=4.68u w=2u l=0.5u
X1 S0 G0 D0 sub sg13_hv_nmos ad=0.68p pd=4.68u as=0.68p ps=4.68u w=2u l=0.5u
.ends

.subckt sg13_hv_nmos_HSMMZS D0 G0 S1 G1 D2 G2 S3 G3 a_314_n100# sub
X0 S3 G2 D2 sub sg13_hv_nmos ad=0.19p pd=1.38u as=0.19p ps=1.38u w=1u l=0.5u
X1 D2 G1 S1 sub sg13_hv_nmos ad=0.19p pd=1.38u as=0.19p ps=1.38u w=1u l=0.5u
X2 S1 G0 D0 sub sg13_hv_nmos ad=0.19p pd=1.38u as=0.34p ps=2.68u w=1u l=0.5u
X3 a_314_n100# G3 S3 sub sg13_hv_nmos ad=0.34p pd=2.68u as=0.19p ps=1.38u w=1u l=0.5u
.ends

.subckt sw_lvl_shift in_n in_p vdd vss out outn
Xsg13_hv_pmos_XRP95E_0 vdd sg13_hv_pmos_XRP95E_0/G1 outn sg13_hv_pmos_XRP95E_0/G1
+ vdd outn out outn vdd vdd sg13_hv_pmos_XRP95E
Xsg13_hv_pmos_2TUKLB_0 sg13_hv_pmos_2TUKLB_0/G1 sg13_hv_pmos_XRP95E_0/G1 vdd sg13_hv_pmos_2TUKLB_0/G1
+ vdd sg13_hv_pmos_XRP95E_0/G1 sg13_hv_pmos_2TUKLB
Xsg13_hv_nmos_CJ33WB_0 vss sg13_hv_pmos_2TUKLB_0/G1 in_p sg13_hv_pmos_XRP95E_0/G1
+ vss in_n vss sg13_hv_nmos_CJ33WB
Xsg13_hv_nmos_HSMMZS_0 vss sg13_hv_pmos_XRP95E_0/G1 outn sg13_hv_pmos_XRP95E_0/G1
+ vss outn out outn vss vss sg13_hv_nmos_HSMMZS
.ends

.subckt sg13cmos5l_decap_4 VDD VSS
X0 VDD VSS VDD VDD sg13_lv_pmos ad=0.34p pd=2.68u as=2.4331p ps=11.58u w=1u l=1u
X1 VSS VDD VSS VSS sg13_lv_nmos ad=0.1428p pd=1.52u as=1.84612p ps=9.32u w=0.42u l=1u
.ends

.subckt sg13cmos5l_inv_4 Y A VDD VSS
X0 Y A VSS VSS sg13_lv_nmos ad=0.1406p pd=1.12u as=0.2516p ps=2.16u w=0.74u l=0.13u
X1 Y A VDD VDD sg13_lv_pmos ad=0.2128p pd=1.5u as=0.3808p ps=2.92u w=1.12u l=0.13u
X2 VSS A Y VSS sg13_lv_nmos ad=0.1406p pd=1.12u as=0.1406p ps=1.12u w=0.74u l=0.13u
X3 Y A VSS VSS sg13_lv_nmos ad=0.1406p pd=1.12u as=0.1406p ps=1.12u w=0.74u l=0.13u
X4 VDD A Y VDD sg13_lv_pmos ad=0.2128p pd=1.5u as=0.2128p ps=1.5u w=1.12u l=0.13u
X5 VSS A Y VSS sg13_lv_nmos ad=0.2516p pd=2.16u as=0.1406p ps=1.12u w=0.74u l=0.13u
X6 Y A VDD VDD sg13_lv_pmos ad=0.2128p pd=1.5u as=0.2128p ps=1.5u w=1.12u l=0.13u
X7 VDD A Y VDD sg13_lv_pmos ad=0.3808p pd=2.92u as=0.2128p ps=1.5u w=1.12u l=0.13u
.ends

.subckt analog_pswitch_small in out dvdd dvss avss enable avdd
Xsg13cmos5l_antennanp_0 enable dvdd dvss sg13cmos5l_antennanp
Xsg13_hv_pmos_HVFXC8_0 avdd out sw_lvl_shift_0/outn in out in out sg13_hv_pmos_HVFXC8
Xsw_lvl_shift_0 sw_lvl_shift_0/in_n sw_lvl_shift_0/in_p avdd avss sw_lvl_shift_0/out
+ sw_lvl_shift_0/outn sw_lvl_shift
Xsg13cmos5l_decap_4_0 dvdd dvss sg13cmos5l_decap_4
Xsg13cmos5l_decap_4_1 dvdd dvss sg13cmos5l_decap_4
Xsg13cmos5l_inv_4_0 sw_lvl_shift_0/in_n enable dvdd dvss sg13cmos5l_inv_4
Xsg13cmos5l_inv_4_1 sw_lvl_shift_0/in_p sw_lvl_shift_0/in_n dvdd dvss sg13cmos5l_inv_4
.ends
