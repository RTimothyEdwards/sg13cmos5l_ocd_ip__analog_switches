* NGSPICE file created from power_stage.ext - technology: ihp-sg13cmos5l

.subckt sg13_hv_nmos_XAVYYR D0 G0 S1 G1 D2 G2 S3 G3 sub a_314_n200#
X0 S3 G2 D2 sub sg13_hv_nmos ad=0.38p pd=2.38u as=0.38p ps=2.38u w=2u l=0.5u
X1 D2 G1 S1 sub sg13_hv_nmos ad=0.38p pd=2.38u as=0.38p ps=2.38u w=2u l=0.5u
X2 S1 G0 D0 sub sg13_hv_nmos ad=0.38p pd=2.38u as=0.68p ps=4.68u w=2u l=0.5u
X3 a_314_n200# G3 S3 sub sg13_hv_nmos ad=0.68p pd=4.68u as=0.38p ps=2.38u w=2u l=0.5u
.ends

.subckt sg13_hv_nmos_3JX36Y D0 G0 S1 G1 D2 G2 S3 G3 D4 G4 S5 G5 D6 G6 S7 G7 D8 G8
+ S9 G9 D10 G10 S11 G11 D12 G12 S13 G13 D14 G14 S15 G15 D16 G16 S17 G17 D18 G18 S19
+ G19 D20 G20 S21 G21 D22 G22 S23 G23 D24 G24 S25 G25 D26 G26 S27 G27 D28 G28 S29
+ G29 D30 G30 S31 G31 D32 G32 S33 G33 D34 G34 S35 G35 D36 G36 S37 G37 D38 G38 S39
+ G39 D40 G40 S41 G41 D42 G42 S43 G43 D44 G44 S45 G45 D46 G46 S47 G47 D48 G48 S49
+ G49 D50 G50 S51 G51 D52 G52 S53 G53 D54 G54 S55 G55 D56 G56 S57 G57 D58 G58 S59
+ G59 D60 G60 S61 G61 D62 G62 S63 G63 D64 G64 S65 G65 D66 G66 S67 G67 D68 G68 S69
+ G69 D70 G70 S71 G71 D72 G72 S73 G73 D74 G74 S75 G75 D76 G76 S77 G77 D78 G78 S79
+ G79 D80 G80 S81 G81 D82 G82 S83 G83 D84 G84 S85 G85 D86 G86 S87 G87 a_7706_n500#
+ sub
X0 S27 G26 D26 sub sg13_hv_nmos ad=0.95p pd=5.38u as=0.95p ps=5.38u w=5u l=0.5u
X1 D46 G45 S45 sub sg13_hv_nmos ad=0.95p pd=5.38u as=0.95p ps=5.38u w=5u l=0.5u
X2 D8 G7 S7 sub sg13_hv_nmos ad=0.95p pd=5.38u as=0.95p ps=5.38u w=5u l=0.5u
X3 S15 G14 D14 sub sg13_hv_nmos ad=0.95p pd=5.38u as=0.95p ps=5.38u w=5u l=0.5u
X4 D42 G41 S41 sub sg13_hv_nmos ad=0.95p pd=5.38u as=0.95p ps=5.38u w=5u l=0.5u
X5 D56 G55 S55 sub sg13_hv_nmos ad=0.95p pd=5.38u as=0.95p ps=5.38u w=5u l=0.5u
X6 D74 G73 S73 sub sg13_hv_nmos ad=0.95p pd=5.38u as=0.95p ps=5.38u w=5u l=0.5u
X7 S81 G80 D80 sub sg13_hv_nmos ad=0.95p pd=5.38u as=0.95p ps=5.38u w=5u l=0.5u
X8 D6 G5 S5 sub sg13_hv_nmos ad=0.95p pd=5.38u as=0.95p ps=5.38u w=5u l=0.5u
X9 S83 G82 D82 sub sg13_hv_nmos ad=0.95p pd=5.38u as=0.95p ps=5.38u w=5u l=0.5u
X10 S19 G18 D18 sub sg13_hv_nmos ad=0.95p pd=5.38u as=0.95p ps=5.38u w=5u l=0.5u
X11 S21 G20 D20 sub sg13_hv_nmos ad=0.95p pd=5.38u as=0.95p ps=5.38u w=5u l=0.5u
X12 D26 G25 S25 sub sg13_hv_nmos ad=0.95p pd=5.38u as=0.95p ps=5.38u w=5u l=0.5u
X13 S63 G62 D62 sub sg13_hv_nmos ad=0.95p pd=5.38u as=0.95p ps=5.38u w=5u l=0.5u
X14 D68 G67 S67 sub sg13_hv_nmos ad=0.95p pd=5.38u as=0.95p ps=5.38u w=5u l=0.5u
X15 D70 G69 S69 sub sg13_hv_nmos ad=0.95p pd=5.38u as=0.95p ps=5.38u w=5u l=0.5u
X16 D12 G11 S11 sub sg13_hv_nmos ad=0.95p pd=5.38u as=0.95p ps=5.38u w=5u l=0.5u
X17 S41 G40 D40 sub sg13_hv_nmos ad=0.95p pd=5.38u as=0.95p ps=5.38u w=5u l=0.5u
X18 D82 G81 S81 sub sg13_hv_nmos ad=0.95p pd=5.38u as=0.95p ps=5.38u w=5u l=0.5u
X19 D84 G83 S83 sub sg13_hv_nmos ad=0.95p pd=5.38u as=0.95p ps=5.38u w=5u l=0.5u
X20 D32 G31 S31 sub sg13_hv_nmos ad=0.95p pd=5.38u as=0.95p ps=5.38u w=5u l=0.5u
X21 S39 G38 D38 sub sg13_hv_nmos ad=0.95p pd=5.38u as=0.95p ps=5.38u w=5u l=0.5u
X22 D48 G47 S47 sub sg13_hv_nmos ad=0.95p pd=5.38u as=0.95p ps=5.38u w=5u l=0.5u
X23 D62 G61 S61 sub sg13_hv_nmos ad=0.95p pd=5.38u as=0.95p ps=5.38u w=5u l=0.5u
X24 S13 G12 D12 sub sg13_hv_nmos ad=0.95p pd=5.38u as=0.95p ps=5.38u w=5u l=0.5u
X25 D18 G17 S17 sub sg13_hv_nmos ad=0.95p pd=5.38u as=0.95p ps=5.38u w=5u l=0.5u
X26 D20 G19 S19 sub sg13_hv_nmos ad=0.95p pd=5.38u as=0.95p ps=5.38u w=5u l=0.5u
X27 D50 G49 S49 sub sg13_hv_nmos ad=0.95p pd=5.38u as=0.95p ps=5.38u w=5u l=0.5u
X28 S69 G68 D68 sub sg13_hv_nmos ad=0.95p pd=5.38u as=0.95p ps=5.38u w=5u l=0.5u
X29 S71 G70 D70 sub sg13_hv_nmos ad=0.95p pd=5.38u as=0.95p ps=5.38u w=5u l=0.5u
X30 D76 G75 S75 sub sg13_hv_nmos ad=0.95p pd=5.38u as=0.95p ps=5.38u w=5u l=0.5u
X31 S11 G10 D10 sub sg13_hv_nmos ad=0.95p pd=5.38u as=0.95p ps=5.38u w=5u l=0.5u
X32 D40 G39 S39 sub sg13_hv_nmos ad=0.95p pd=5.38u as=0.95p ps=5.38u w=5u l=0.5u
X33 D78 G77 S77 sub sg13_hv_nmos ad=0.95p pd=5.38u as=0.95p ps=5.38u w=5u l=0.5u
X34 S33 G32 D32 sub sg13_hv_nmos ad=0.95p pd=5.38u as=0.95p ps=5.38u w=5u l=0.5u
X35 S47 G46 D46 sub sg13_hv_nmos ad=0.95p pd=5.38u as=0.95p ps=5.38u w=5u l=0.5u
X36 D58 G57 S57 sub sg13_hv_nmos ad=0.95p pd=5.38u as=0.95p ps=5.38u w=5u l=0.5u
X37 D24 G23 S23 sub sg13_hv_nmos ad=0.95p pd=5.38u as=0.95p ps=5.38u w=5u l=0.5u
X38 S31 G30 D30 sub sg13_hv_nmos ad=0.95p pd=5.38u as=0.95p ps=5.38u w=5u l=0.5u
X39 S49 G48 D48 sub sg13_hv_nmos ad=0.95p pd=5.38u as=0.95p ps=5.38u w=5u l=0.5u
X40 S65 G64 D64 sub sg13_hv_nmos ad=0.95p pd=5.38u as=0.95p ps=5.38u w=5u l=0.5u
X41 S17 G16 D16 sub sg13_hv_nmos ad=0.95p pd=5.38u as=0.95p ps=5.38u w=5u l=0.5u
X42 S77 G76 D76 sub sg13_hv_nmos ad=0.95p pd=5.38u as=0.95p ps=5.38u w=5u l=0.5u
X43 S37 G36 D36 sub sg13_hv_nmos ad=0.95p pd=5.38u as=0.95p ps=5.38u w=5u l=0.5u
X44 S57 G56 D56 sub sg13_hv_nmos ad=0.95p pd=5.38u as=0.95p ps=5.38u w=5u l=0.5u
X45 S5 G4 D4 sub sg13_hv_nmos ad=0.95p pd=5.38u as=0.95p ps=5.38u w=5u l=0.5u
X46 S23 G22 D22 sub sg13_hv_nmos ad=0.95p pd=5.38u as=0.95p ps=5.38u w=5u l=0.5u
X47 S25 G24 D24 sub sg13_hv_nmos ad=0.95p pd=5.38u as=0.95p ps=5.38u w=5u l=0.5u
X48 D30 G29 S29 sub sg13_hv_nmos ad=0.95p pd=5.38u as=0.95p ps=5.38u w=5u l=0.5u
X49 S45 G44 D44 sub sg13_hv_nmos ad=0.95p pd=5.38u as=0.95p ps=5.38u w=5u l=0.5u
X50 S59 G58 D58 sub sg13_hv_nmos ad=0.95p pd=5.38u as=0.95p ps=5.38u w=5u l=0.5u
X51 D64 G63 S63 sub sg13_hv_nmos ad=0.95p pd=5.38u as=0.95p ps=5.38u w=5u l=0.5u
X52 D66 G65 S65 sub sg13_hv_nmos ad=0.95p pd=5.38u as=0.95p ps=5.38u w=5u l=0.5u
X53 S73 G72 D72 sub sg13_hv_nmos ad=0.95p pd=5.38u as=0.95p ps=5.38u w=5u l=0.5u
X54 D38 G37 S37 sub sg13_hv_nmos ad=0.95p pd=5.38u as=0.95p ps=5.38u w=5u l=0.5u
X55 S51 G50 D50 sub sg13_hv_nmos ad=0.95p pd=5.38u as=0.95p ps=5.38u w=5u l=0.5u
X56 S53 G52 D52 sub sg13_hv_nmos ad=0.95p pd=5.38u as=0.95p ps=5.38u w=5u l=0.5u
X57 D4 G3 S3 sub sg13_hv_nmos ad=0.95p pd=5.38u as=0.95p ps=5.38u w=5u l=0.5u
X58 S29 G28 D28 sub sg13_hv_nmos ad=0.95p pd=5.38u as=0.95p ps=5.38u w=5u l=0.5u
X59 D36 G35 S35 sub sg13_hv_nmos ad=0.95p pd=5.38u as=0.95p ps=5.38u w=5u l=0.5u
X60 D60 G59 S59 sub sg13_hv_nmos ad=0.95p pd=5.38u as=0.95p ps=5.38u w=5u l=0.5u
X61 S85 G84 D84 sub sg13_hv_nmos ad=0.95p pd=5.38u as=0.95p ps=5.38u w=5u l=0.5u
X62 D2 G1 S1 sub sg13_hv_nmos ad=0.95p pd=5.38u as=0.95p ps=5.38u w=5u l=0.5u
X63 S67 G66 D66 sub sg13_hv_nmos ad=0.95p pd=5.38u as=0.95p ps=5.38u w=5u l=0.5u
X64 D72 G71 S71 sub sg13_hv_nmos ad=0.95p pd=5.38u as=0.95p ps=5.38u w=5u l=0.5u
X65 D22 G21 S21 sub sg13_hv_nmos ad=0.95p pd=5.38u as=0.95p ps=5.38u w=5u l=0.5u
X66 D52 G51 S51 sub sg13_hv_nmos ad=0.95p pd=5.38u as=0.95p ps=5.38u w=5u l=0.5u
X67 S3 G2 D2 sub sg13_hv_nmos ad=0.95p pd=5.38u as=0.95p ps=5.38u w=5u l=0.5u
X68 D10 G9 S9 sub sg13_hv_nmos ad=0.95p pd=5.38u as=0.95p ps=5.38u w=5u l=0.5u
X69 D28 G27 S27 sub sg13_hv_nmos ad=0.95p pd=5.38u as=0.95p ps=5.38u w=5u l=0.5u
X70 S35 G34 D34 sub sg13_hv_nmos ad=0.95p pd=5.38u as=0.95p ps=5.38u w=5u l=0.5u
X71 D44 G43 S43 sub sg13_hv_nmos ad=0.95p pd=5.38u as=0.95p ps=5.38u w=5u l=0.5u
X72 D54 G53 S53 sub sg13_hv_nmos ad=0.95p pd=5.38u as=0.95p ps=5.38u w=5u l=0.5u
X73 S61 G60 D60 sub sg13_hv_nmos ad=0.95p pd=5.38u as=0.95p ps=5.38u w=5u l=0.5u
X74 S79 G78 D78 sub sg13_hv_nmos ad=0.95p pd=5.38u as=0.95p ps=5.38u w=5u l=0.5u
X75 D86 G85 S85 sub sg13_hv_nmos ad=0.95p pd=5.38u as=0.95p ps=5.38u w=5u l=0.5u
X76 S1 G0 D0 sub sg13_hv_nmos ad=0.95p pd=5.38u as=1.7p ps=10.68u w=5u l=0.5u
X77 a_7706_n500# G87 S87 sub sg13_hv_nmos ad=1.7p pd=10.68u as=0.95p ps=5.38u w=5u l=0.5u
X78 S9 G8 D8 sub sg13_hv_nmos ad=0.95p pd=5.38u as=0.95p ps=5.38u w=5u l=0.5u
X79 D14 G13 S13 sub sg13_hv_nmos ad=0.95p pd=5.38u as=0.95p ps=5.38u w=5u l=0.5u
X80 D16 G15 S15 sub sg13_hv_nmos ad=0.95p pd=5.38u as=0.95p ps=5.38u w=5u l=0.5u
X81 D34 G33 S33 sub sg13_hv_nmos ad=0.95p pd=5.38u as=0.95p ps=5.38u w=5u l=0.5u
X82 S43 G42 D42 sub sg13_hv_nmos ad=0.95p pd=5.38u as=0.95p ps=5.38u w=5u l=0.5u
X83 S55 G54 D54 sub sg13_hv_nmos ad=0.95p pd=5.38u as=0.95p ps=5.38u w=5u l=0.5u
X84 S75 G74 D74 sub sg13_hv_nmos ad=0.95p pd=5.38u as=0.95p ps=5.38u w=5u l=0.5u
X85 D80 G79 S79 sub sg13_hv_nmos ad=0.95p pd=5.38u as=0.95p ps=5.38u w=5u l=0.5u
X86 S7 G6 D6 sub sg13_hv_nmos ad=0.95p pd=5.38u as=0.95p ps=5.38u w=5u l=0.5u
X87 S87 G86 D86 sub sg13_hv_nmos ad=0.95p pd=5.38u as=0.95p ps=5.38u w=5u l=0.5u
.ends

.subckt sg13_hv_pmos_YZSTZS D0 G0 S1 G1 D2 G2 S3 G3 a_314_n400# w_n506_n524#
X0 D2 G1 S1 w_n506_n524# sg13_hv_pmos ad=0.76p pd=4.38u as=0.76p ps=4.38u w=4u l=0.5u
X1 S1 G0 D0 w_n506_n524# sg13_hv_pmos ad=0.76p pd=4.38u as=1.36p ps=8.68u w=4u l=0.5u
X2 a_314_n400# G3 S3 w_n506_n524# sg13_hv_pmos ad=1.36p pd=8.68u as=0.76p ps=4.38u w=4u l=0.5u
X3 S3 G2 D2 w_n506_n524# sg13_hv_pmos ad=0.76p pd=4.38u as=0.76p ps=4.38u w=4u l=0.5u
.ends

.subckt sg13_hv_pmos_RQMCRC D0 G0 S1 G1 D2 G2 S3 G3 D4 G4 S5 G5 D6 G6 S7 G7 D8 G8
+ S9 G9 D10 G10 S11 G11 D12 G12 S13 G13 D14 G14 S15 G15 D16 G16 S17 G17 D18 G18 S19
+ G19 D20 G20 S21 G21 D22 G22 S23 G23 D24 G24 S25 G25 D26 G26 S27 G27 D28 G28 S29
+ G29 D30 G30 S31 G31 D32 G32 S33 G33 D34 G34 S35 G35 D36 G36 S37 G37 D38 G38 S39
+ G39 D40 G40 S41 G41 D42 G42 S43 G43 D44 G44 S45 G45 D46 G46 S47 G47 D48 G48 S49
+ G49 D50 G50 S51 G51 D52 G52 S53 G53 D54 G54 S55 G55 D56 G56 S57 G57 D58 G58 S59
+ G59 D60 G60 S61 G61 D62 G62 S63 G63 D64 G64 S65 G65 D66 G66 S67 G67 D68 G68 S69
+ G69 D70 G70 S71 G71 D72 G72 S73 G73 D74 G74 S75 G75 D76 G76 S77 G77 D78 G78 S79
+ G79 D80 G80 S81 G81 D82 G82 S83 G83 D84 G84 S85 G85 D86 G86 S87 G87 w_n7898_n1124#
+ a_7706_n1000#
X0 D30 G29 S29 w_n7898_n1124# sg13_hv_pmos ad=1.9p pd=10.38u as=1.9p ps=10.38u w=10u l=0.5u
X1 S37 G36 D36 w_n7898_n1124# sg13_hv_pmos ad=1.9p pd=10.38u as=1.9p ps=10.38u w=10u l=0.5u
X2 S45 G44 D44 w_n7898_n1124# sg13_hv_pmos ad=1.9p pd=10.38u as=1.9p ps=10.38u w=10u l=0.5u
X3 S57 G56 D56 w_n7898_n1124# sg13_hv_pmos ad=1.9p pd=10.38u as=1.9p ps=10.38u w=10u l=0.5u
X4 S59 G58 D58 w_n7898_n1124# sg13_hv_pmos ad=1.9p pd=10.38u as=1.9p ps=10.38u w=10u l=0.5u
X5 D64 G63 S63 w_n7898_n1124# sg13_hv_pmos ad=1.9p pd=10.38u as=1.9p ps=10.38u w=10u l=0.5u
X6 S5 G4 D4 w_n7898_n1124# sg13_hv_pmos ad=1.9p pd=10.38u as=1.9p ps=10.38u w=10u l=0.5u
X7 S23 G22 D22 w_n7898_n1124# sg13_hv_pmos ad=1.9p pd=10.38u as=1.9p ps=10.38u w=10u l=0.5u
X8 S25 G24 D24 w_n7898_n1124# sg13_hv_pmos ad=1.9p pd=10.38u as=1.9p ps=10.38u w=10u l=0.5u
X9 D66 G65 S65 w_n7898_n1124# sg13_hv_pmos ad=1.9p pd=10.38u as=1.9p ps=10.38u w=10u l=0.5u
X10 S73 G72 D72 w_n7898_n1124# sg13_hv_pmos ad=1.9p pd=10.38u as=1.9p ps=10.38u w=10u l=0.5u
X11 D36 G35 S35 w_n7898_n1124# sg13_hv_pmos ad=1.9p pd=10.38u as=1.9p ps=10.38u w=10u l=0.5u
X12 D38 G37 S37 w_n7898_n1124# sg13_hv_pmos ad=1.9p pd=10.38u as=1.9p ps=10.38u w=10u l=0.5u
X13 S51 G50 D50 w_n7898_n1124# sg13_hv_pmos ad=1.9p pd=10.38u as=1.9p ps=10.38u w=10u l=0.5u
X14 S53 G52 D52 w_n7898_n1124# sg13_hv_pmos ad=1.9p pd=10.38u as=1.9p ps=10.38u w=10u l=0.5u
X15 D60 G59 S59 w_n7898_n1124# sg13_hv_pmos ad=1.9p pd=10.38u as=1.9p ps=10.38u w=10u l=0.5u
X16 D2 G1 S1 w_n7898_n1124# sg13_hv_pmos ad=1.9p pd=10.38u as=1.9p ps=10.38u w=10u l=0.5u
X17 D4 G3 S3 w_n7898_n1124# sg13_hv_pmos ad=1.9p pd=10.38u as=1.9p ps=10.38u w=10u l=0.5u
X18 S29 G28 D28 w_n7898_n1124# sg13_hv_pmos ad=1.9p pd=10.38u as=1.9p ps=10.38u w=10u l=0.5u
X19 S67 G66 D66 w_n7898_n1124# sg13_hv_pmos ad=1.9p pd=10.38u as=1.9p ps=10.38u w=10u l=0.5u
X20 D72 G71 S71 w_n7898_n1124# sg13_hv_pmos ad=1.9p pd=10.38u as=1.9p ps=10.38u w=10u l=0.5u
X21 S85 G84 D84 w_n7898_n1124# sg13_hv_pmos ad=1.9p pd=10.38u as=1.9p ps=10.38u w=10u l=0.5u
X22 D22 G21 S21 w_n7898_n1124# sg13_hv_pmos ad=1.9p pd=10.38u as=1.9p ps=10.38u w=10u l=0.5u
X23 S35 G34 D34 w_n7898_n1124# sg13_hv_pmos ad=1.9p pd=10.38u as=1.9p ps=10.38u w=10u l=0.5u
X24 D44 G43 S43 w_n7898_n1124# sg13_hv_pmos ad=1.9p pd=10.38u as=1.9p ps=10.38u w=10u l=0.5u
X25 D52 G51 S51 w_n7898_n1124# sg13_hv_pmos ad=1.9p pd=10.38u as=1.9p ps=10.38u w=10u l=0.5u
X26 D54 G53 S53 w_n7898_n1124# sg13_hv_pmos ad=1.9p pd=10.38u as=1.9p ps=10.38u w=10u l=0.5u
X27 S79 G78 D78 w_n7898_n1124# sg13_hv_pmos ad=1.9p pd=10.38u as=1.9p ps=10.38u w=10u l=0.5u
X28 S1 G0 D0 w_n7898_n1124# sg13_hv_pmos ad=1.9p pd=10.38u as=3.4p ps=20.68u w=10u l=0.5u
X29 S3 G2 D2 w_n7898_n1124# sg13_hv_pmos ad=1.9p pd=10.38u as=1.9p ps=10.38u w=10u l=0.5u
X30 D10 G9 S9 w_n7898_n1124# sg13_hv_pmos ad=1.9p pd=10.38u as=1.9p ps=10.38u w=10u l=0.5u
X31 D28 G27 S27 w_n7898_n1124# sg13_hv_pmos ad=1.9p pd=10.38u as=1.9p ps=10.38u w=10u l=0.5u
X32 S61 G60 D60 w_n7898_n1124# sg13_hv_pmos ad=1.9p pd=10.38u as=1.9p ps=10.38u w=10u l=0.5u
X33 D86 G85 S85 w_n7898_n1124# sg13_hv_pmos ad=1.9p pd=10.38u as=1.9p ps=10.38u w=10u l=0.5u
X34 a_7706_n1000# G87 S87 w_n7898_n1124# sg13_hv_pmos ad=3.4p pd=20.68u as=1.9p ps=10.38u w=10u l=0.5u
X35 D16 G15 S15 w_n7898_n1124# sg13_hv_pmos ad=1.9p pd=10.38u as=1.9p ps=10.38u w=10u l=0.5u
X36 S55 G54 D54 w_n7898_n1124# sg13_hv_pmos ad=1.9p pd=10.38u as=1.9p ps=10.38u w=10u l=0.5u
X37 S75 G74 D74 w_n7898_n1124# sg13_hv_pmos ad=1.9p pd=10.38u as=1.9p ps=10.38u w=10u l=0.5u
X38 S7 G6 D6 w_n7898_n1124# sg13_hv_pmos ad=1.9p pd=10.38u as=1.9p ps=10.38u w=10u l=0.5u
X39 S9 G8 D8 w_n7898_n1124# sg13_hv_pmos ad=1.9p pd=10.38u as=1.9p ps=10.38u w=10u l=0.5u
X40 D14 G13 S13 w_n7898_n1124# sg13_hv_pmos ad=1.9p pd=10.38u as=1.9p ps=10.38u w=10u l=0.5u
X41 D34 G33 S33 w_n7898_n1124# sg13_hv_pmos ad=1.9p pd=10.38u as=1.9p ps=10.38u w=10u l=0.5u
X42 S43 G42 D42 w_n7898_n1124# sg13_hv_pmos ad=1.9p pd=10.38u as=1.9p ps=10.38u w=10u l=0.5u
X43 D80 G79 S79 w_n7898_n1124# sg13_hv_pmos ad=1.9p pd=10.38u as=1.9p ps=10.38u w=10u l=0.5u
X44 S87 G86 D86 w_n7898_n1124# sg13_hv_pmos ad=1.9p pd=10.38u as=1.9p ps=10.38u w=10u l=0.5u
X45 D46 G45 S45 w_n7898_n1124# sg13_hv_pmos ad=1.9p pd=10.38u as=1.9p ps=10.38u w=10u l=0.5u
X46 S27 G26 D26 w_n7898_n1124# sg13_hv_pmos ad=1.9p pd=10.38u as=1.9p ps=10.38u w=10u l=0.5u
X47 D74 G73 S73 w_n7898_n1124# sg13_hv_pmos ad=1.9p pd=10.38u as=1.9p ps=10.38u w=10u l=0.5u
X48 D6 G5 S5 w_n7898_n1124# sg13_hv_pmos ad=1.9p pd=10.38u as=1.9p ps=10.38u w=10u l=0.5u
X49 D8 G7 S7 w_n7898_n1124# sg13_hv_pmos ad=1.9p pd=10.38u as=1.9p ps=10.38u w=10u l=0.5u
X50 S15 G14 D14 w_n7898_n1124# sg13_hv_pmos ad=1.9p pd=10.38u as=1.9p ps=10.38u w=10u l=0.5u
X51 D42 G41 S41 w_n7898_n1124# sg13_hv_pmos ad=1.9p pd=10.38u as=1.9p ps=10.38u w=10u l=0.5u
X52 D56 G55 S55 w_n7898_n1124# sg13_hv_pmos ad=1.9p pd=10.38u as=1.9p ps=10.38u w=10u l=0.5u
X53 S81 G80 D80 w_n7898_n1124# sg13_hv_pmos ad=1.9p pd=10.38u as=1.9p ps=10.38u w=10u l=0.5u
X54 S83 G82 D82 w_n7898_n1124# sg13_hv_pmos ad=1.9p pd=10.38u as=1.9p ps=10.38u w=10u l=0.5u
X55 S21 G20 D20 w_n7898_n1124# sg13_hv_pmos ad=1.9p pd=10.38u as=1.9p ps=10.38u w=10u l=0.5u
X56 D26 G25 S25 w_n7898_n1124# sg13_hv_pmos ad=1.9p pd=10.38u as=1.9p ps=10.38u w=10u l=0.5u
X57 S63 G62 D62 w_n7898_n1124# sg13_hv_pmos ad=1.9p pd=10.38u as=1.9p ps=10.38u w=10u l=0.5u
X58 D68 G67 S67 w_n7898_n1124# sg13_hv_pmos ad=1.9p pd=10.38u as=1.9p ps=10.38u w=10u l=0.5u
X59 D70 G69 S69 w_n7898_n1124# sg13_hv_pmos ad=1.9p pd=10.38u as=1.9p ps=10.38u w=10u l=0.5u
X60 D12 G11 S11 w_n7898_n1124# sg13_hv_pmos ad=1.9p pd=10.38u as=1.9p ps=10.38u w=10u l=0.5u
X61 S19 G18 D18 w_n7898_n1124# sg13_hv_pmos ad=1.9p pd=10.38u as=1.9p ps=10.38u w=10u l=0.5u
X62 S41 G40 D40 w_n7898_n1124# sg13_hv_pmos ad=1.9p pd=10.38u as=1.9p ps=10.38u w=10u l=0.5u
X63 D82 G81 S81 w_n7898_n1124# sg13_hv_pmos ad=1.9p pd=10.38u as=1.9p ps=10.38u w=10u l=0.5u
X64 D84 G83 S83 w_n7898_n1124# sg13_hv_pmos ad=1.9p pd=10.38u as=1.9p ps=10.38u w=10u l=0.5u
X65 S39 G38 D38 w_n7898_n1124# sg13_hv_pmos ad=1.9p pd=10.38u as=1.9p ps=10.38u w=10u l=0.5u
X66 D32 G31 S31 w_n7898_n1124# sg13_hv_pmos ad=1.9p pd=10.38u as=1.9p ps=10.38u w=10u l=0.5u
X67 D48 G47 S47 w_n7898_n1124# sg13_hv_pmos ad=1.9p pd=10.38u as=1.9p ps=10.38u w=10u l=0.5u
X68 D50 G49 S49 w_n7898_n1124# sg13_hv_pmos ad=1.9p pd=10.38u as=1.9p ps=10.38u w=10u l=0.5u
X69 D62 G61 S61 w_n7898_n1124# sg13_hv_pmos ad=1.9p pd=10.38u as=1.9p ps=10.38u w=10u l=0.5u
X70 S69 G68 D68 w_n7898_n1124# sg13_hv_pmos ad=1.9p pd=10.38u as=1.9p ps=10.38u w=10u l=0.5u
X71 S11 G10 D10 w_n7898_n1124# sg13_hv_pmos ad=1.9p pd=10.38u as=1.9p ps=10.38u w=10u l=0.5u
X72 S13 G12 D12 w_n7898_n1124# sg13_hv_pmos ad=1.9p pd=10.38u as=1.9p ps=10.38u w=10u l=0.5u
X73 D18 G17 S17 w_n7898_n1124# sg13_hv_pmos ad=1.9p pd=10.38u as=1.9p ps=10.38u w=10u l=0.5u
X74 D20 G19 S19 w_n7898_n1124# sg13_hv_pmos ad=1.9p pd=10.38u as=1.9p ps=10.38u w=10u l=0.5u
X75 D40 G39 S39 w_n7898_n1124# sg13_hv_pmos ad=1.9p pd=10.38u as=1.9p ps=10.38u w=10u l=0.5u
X76 S71 G70 D70 w_n7898_n1124# sg13_hv_pmos ad=1.9p pd=10.38u as=1.9p ps=10.38u w=10u l=0.5u
X77 D76 G75 S75 w_n7898_n1124# sg13_hv_pmos ad=1.9p pd=10.38u as=1.9p ps=10.38u w=10u l=0.5u
X78 D78 G77 S77 w_n7898_n1124# sg13_hv_pmos ad=1.9p pd=10.38u as=1.9p ps=10.38u w=10u l=0.5u
X79 S31 G30 D30 w_n7898_n1124# sg13_hv_pmos ad=1.9p pd=10.38u as=1.9p ps=10.38u w=10u l=0.5u
X80 S33 G32 D32 w_n7898_n1124# sg13_hv_pmos ad=1.9p pd=10.38u as=1.9p ps=10.38u w=10u l=0.5u
X81 S47 G46 D46 w_n7898_n1124# sg13_hv_pmos ad=1.9p pd=10.38u as=1.9p ps=10.38u w=10u l=0.5u
X82 S49 G48 D48 w_n7898_n1124# sg13_hv_pmos ad=1.9p pd=10.38u as=1.9p ps=10.38u w=10u l=0.5u
X83 D58 G57 S57 w_n7898_n1124# sg13_hv_pmos ad=1.9p pd=10.38u as=1.9p ps=10.38u w=10u l=0.5u
X84 S65 G64 D64 w_n7898_n1124# sg13_hv_pmos ad=1.9p pd=10.38u as=1.9p ps=10.38u w=10u l=0.5u
X85 S17 G16 D16 w_n7898_n1124# sg13_hv_pmos ad=1.9p pd=10.38u as=1.9p ps=10.38u w=10u l=0.5u
X86 D24 G23 S23 w_n7898_n1124# sg13_hv_pmos ad=1.9p pd=10.38u as=1.9p ps=10.38u w=10u l=0.5u
X87 S77 G76 D76 w_n7898_n1124# sg13_hv_pmos ad=1.9p pd=10.38u as=1.9p ps=10.38u w=10u l=0.5u
.ends

.subckt gate_drive in_p in_n vss vdd out
Xsg13_hv_nmos_XAVYYR_0 vss in_p sg13_hv_pmos_YZSTZS_0/S1 in_p vss in_n sg13_hv_pmos_YZSTZS_0/S3
+ in_n vss vss sg13_hv_nmos_XAVYYR
Xsg13_hv_nmos_3JX36Y_0 vss sg13_hv_pmos_YZSTZS_0/S3 sg13_hv_pmos_RQMCRC_0/S1 sg13_hv_pmos_YZSTZS_0/S3
+ vss sg13_hv_pmos_RQMCRC_0/S1 sg13_hv_pmos_RQMCRC_0/S7 sg13_hv_pmos_RQMCRC_0/S1 vss
+ sg13_hv_pmos_RQMCRC_0/S1 sg13_hv_pmos_RQMCRC_0/S7 sg13_hv_pmos_RQMCRC_0/S1 vss sg13_hv_pmos_RQMCRC_0/S1
+ sg13_hv_pmos_RQMCRC_0/S7 sg13_hv_pmos_RQMCRC_0/S1 vss sg13_hv_pmos_RQMCRC_0/S7 sg13_hv_pmos_RQMCRC_0/S9
+ sg13_hv_pmos_RQMCRC_0/S7 vss sg13_hv_pmos_RQMCRC_0/S7 sg13_hv_pmos_RQMCRC_0/S9 sg13_hv_pmos_RQMCRC_0/S7
+ vss sg13_hv_pmos_RQMCRC_0/S7 sg13_hv_pmos_RQMCRC_0/S9 sg13_hv_pmos_RQMCRC_0/S7 vss
+ sg13_hv_pmos_RQMCRC_0/S7 sg13_hv_pmos_RQMCRC_0/S9 sg13_hv_pmos_RQMCRC_0/S7 vss sg13_hv_pmos_RQMCRC_0/S7
+ sg13_hv_pmos_RQMCRC_0/S9 sg13_hv_pmos_RQMCRC_0/S7 vss sg13_hv_pmos_RQMCRC_0/S7 sg13_hv_pmos_RQMCRC_0/S9
+ sg13_hv_pmos_RQMCRC_0/S7 vss sg13_hv_pmos_RQMCRC_0/S7 sg13_hv_pmos_RQMCRC_0/S9 sg13_hv_pmos_RQMCRC_0/S7
+ vss sg13_hv_pmos_RQMCRC_0/S7 sg13_hv_pmos_RQMCRC_0/S9 sg13_hv_pmos_RQMCRC_0/S7 vss
+ sg13_hv_pmos_RQMCRC_0/S7 sg13_hv_pmos_RQMCRC_0/S9 sg13_hv_pmos_RQMCRC_0/S7 vss sg13_hv_pmos_RQMCRC_0/S7
+ sg13_hv_pmos_RQMCRC_0/S9 sg13_hv_pmos_RQMCRC_0/S7 vss sg13_hv_pmos_RQMCRC_0/S9 out
+ sg13_hv_pmos_RQMCRC_0/S9 vss sg13_hv_pmos_RQMCRC_0/S9 out sg13_hv_pmos_RQMCRC_0/S9
+ vss sg13_hv_pmos_RQMCRC_0/S9 out sg13_hv_pmos_RQMCRC_0/S9 vss sg13_hv_pmos_RQMCRC_0/S9
+ out sg13_hv_pmos_RQMCRC_0/S9 vss sg13_hv_pmos_RQMCRC_0/S9 out sg13_hv_pmos_RQMCRC_0/S9
+ vss sg13_hv_pmos_RQMCRC_0/S9 out sg13_hv_pmos_RQMCRC_0/S9 vss sg13_hv_pmos_RQMCRC_0/S9
+ out sg13_hv_pmos_RQMCRC_0/S9 vss sg13_hv_pmos_RQMCRC_0/S9 out sg13_hv_pmos_RQMCRC_0/S9
+ vss sg13_hv_pmos_RQMCRC_0/S9 out sg13_hv_pmos_RQMCRC_0/S9 vss sg13_hv_pmos_RQMCRC_0/S9
+ out sg13_hv_pmos_RQMCRC_0/S9 vss sg13_hv_pmos_RQMCRC_0/S9 out sg13_hv_pmos_RQMCRC_0/S9
+ vss sg13_hv_pmos_RQMCRC_0/S9 out sg13_hv_pmos_RQMCRC_0/S9 vss sg13_hv_pmos_RQMCRC_0/S9
+ out sg13_hv_pmos_RQMCRC_0/S9 vss sg13_hv_pmos_RQMCRC_0/S9 out sg13_hv_pmos_RQMCRC_0/S9
+ vss sg13_hv_pmos_RQMCRC_0/S9 out sg13_hv_pmos_RQMCRC_0/S9 vss sg13_hv_pmos_RQMCRC_0/S9
+ out sg13_hv_pmos_RQMCRC_0/S9 vss sg13_hv_pmos_RQMCRC_0/S9 out sg13_hv_pmos_RQMCRC_0/S9
+ vss sg13_hv_pmos_RQMCRC_0/S9 out sg13_hv_pmos_RQMCRC_0/S9 vss sg13_hv_pmos_RQMCRC_0/S9
+ out sg13_hv_pmos_RQMCRC_0/S9 vss sg13_hv_pmos_RQMCRC_0/S9 out sg13_hv_pmos_RQMCRC_0/S9
+ vss sg13_hv_pmos_RQMCRC_0/S9 out sg13_hv_pmos_RQMCRC_0/S9 vss sg13_hv_pmos_RQMCRC_0/S9
+ out sg13_hv_pmos_RQMCRC_0/S9 vss sg13_hv_pmos_RQMCRC_0/S9 out sg13_hv_pmos_RQMCRC_0/S9
+ vss sg13_hv_pmos_RQMCRC_0/S9 out sg13_hv_pmos_RQMCRC_0/S9 vss sg13_hv_pmos_RQMCRC_0/S9
+ out sg13_hv_pmos_RQMCRC_0/S9 vss sg13_hv_pmos_RQMCRC_0/S9 out sg13_hv_pmos_RQMCRC_0/S9
+ vss sg13_hv_pmos_RQMCRC_0/S9 out sg13_hv_pmos_RQMCRC_0/S9 vss sg13_hv_pmos_RQMCRC_0/S9
+ out sg13_hv_pmos_RQMCRC_0/S9 vss sg13_hv_pmos_RQMCRC_0/S9 out sg13_hv_pmos_RQMCRC_0/S9
+ vss sg13_hv_pmos_RQMCRC_0/S9 out sg13_hv_pmos_RQMCRC_0/S9 vss vss sg13_hv_nmos_3JX36Y
Xsg13_hv_pmos_YZSTZS_0 vdd sg13_hv_pmos_YZSTZS_0/S3 sg13_hv_pmos_YZSTZS_0/S1 sg13_hv_pmos_YZSTZS_0/S3
+ vdd sg13_hv_pmos_YZSTZS_0/S1 sg13_hv_pmos_YZSTZS_0/S3 sg13_hv_pmos_YZSTZS_0/S1 vdd
+ vdd sg13_hv_pmos_YZSTZS
Xsg13_hv_pmos_RQMCRC_0 vdd sg13_hv_pmos_YZSTZS_0/S3 sg13_hv_pmos_RQMCRC_0/S1 sg13_hv_pmos_YZSTZS_0/S3
+ vdd sg13_hv_pmos_RQMCRC_0/S1 sg13_hv_pmos_RQMCRC_0/S7 sg13_hv_pmos_RQMCRC_0/S1 vdd
+ sg13_hv_pmos_RQMCRC_0/S1 sg13_hv_pmos_RQMCRC_0/S7 sg13_hv_pmos_RQMCRC_0/S1 vdd sg13_hv_pmos_RQMCRC_0/S1
+ sg13_hv_pmos_RQMCRC_0/S7 sg13_hv_pmos_RQMCRC_0/S1 vdd sg13_hv_pmos_RQMCRC_0/S7 sg13_hv_pmos_RQMCRC_0/S9
+ sg13_hv_pmos_RQMCRC_0/S7 vdd sg13_hv_pmos_RQMCRC_0/S7 sg13_hv_pmos_RQMCRC_0/S9 sg13_hv_pmos_RQMCRC_0/S7
+ vdd sg13_hv_pmos_RQMCRC_0/S7 sg13_hv_pmos_RQMCRC_0/S9 sg13_hv_pmos_RQMCRC_0/S7 vdd
+ sg13_hv_pmos_RQMCRC_0/S7 sg13_hv_pmos_RQMCRC_0/S9 sg13_hv_pmos_RQMCRC_0/S7 vdd sg13_hv_pmos_RQMCRC_0/S7
+ sg13_hv_pmos_RQMCRC_0/S9 sg13_hv_pmos_RQMCRC_0/S7 vdd sg13_hv_pmos_RQMCRC_0/S7 sg13_hv_pmos_RQMCRC_0/S9
+ sg13_hv_pmos_RQMCRC_0/S7 vdd sg13_hv_pmos_RQMCRC_0/S7 sg13_hv_pmos_RQMCRC_0/S9 sg13_hv_pmos_RQMCRC_0/S7
+ vdd sg13_hv_pmos_RQMCRC_0/S7 sg13_hv_pmos_RQMCRC_0/S9 sg13_hv_pmos_RQMCRC_0/S7 vdd
+ sg13_hv_pmos_RQMCRC_0/S7 sg13_hv_pmos_RQMCRC_0/S9 sg13_hv_pmos_RQMCRC_0/S7 vdd sg13_hv_pmos_RQMCRC_0/S7
+ sg13_hv_pmos_RQMCRC_0/S9 sg13_hv_pmos_RQMCRC_0/S7 vdd sg13_hv_pmos_RQMCRC_0/S9 out
+ sg13_hv_pmos_RQMCRC_0/S9 vdd sg13_hv_pmos_RQMCRC_0/S9 out sg13_hv_pmos_RQMCRC_0/S9
+ vdd sg13_hv_pmos_RQMCRC_0/S9 out sg13_hv_pmos_RQMCRC_0/S9 vdd sg13_hv_pmos_RQMCRC_0/S9
+ out sg13_hv_pmos_RQMCRC_0/S9 vdd sg13_hv_pmos_RQMCRC_0/S9 out sg13_hv_pmos_RQMCRC_0/S9
+ vdd sg13_hv_pmos_RQMCRC_0/S9 out sg13_hv_pmos_RQMCRC_0/S9 vdd sg13_hv_pmos_RQMCRC_0/S9
+ out sg13_hv_pmos_RQMCRC_0/S9 vdd sg13_hv_pmos_RQMCRC_0/S9 out sg13_hv_pmos_RQMCRC_0/S9
+ vdd sg13_hv_pmos_RQMCRC_0/S9 out sg13_hv_pmos_RQMCRC_0/S9 vdd sg13_hv_pmos_RQMCRC_0/S9
+ out sg13_hv_pmos_RQMCRC_0/S9 vdd sg13_hv_pmos_RQMCRC_0/S9 out sg13_hv_pmos_RQMCRC_0/S9
+ vdd sg13_hv_pmos_RQMCRC_0/S9 out sg13_hv_pmos_RQMCRC_0/S9 vdd sg13_hv_pmos_RQMCRC_0/S9
+ out sg13_hv_pmos_RQMCRC_0/S9 vdd sg13_hv_pmos_RQMCRC_0/S9 out sg13_hv_pmos_RQMCRC_0/S9
+ vdd sg13_hv_pmos_RQMCRC_0/S9 out sg13_hv_pmos_RQMCRC_0/S9 vdd sg13_hv_pmos_RQMCRC_0/S9
+ out sg13_hv_pmos_RQMCRC_0/S9 vdd sg13_hv_pmos_RQMCRC_0/S9 out sg13_hv_pmos_RQMCRC_0/S9
+ vdd sg13_hv_pmos_RQMCRC_0/S9 out sg13_hv_pmos_RQMCRC_0/S9 vdd sg13_hv_pmos_RQMCRC_0/S9
+ out sg13_hv_pmos_RQMCRC_0/S9 vdd sg13_hv_pmos_RQMCRC_0/S9 out sg13_hv_pmos_RQMCRC_0/S9
+ vdd sg13_hv_pmos_RQMCRC_0/S9 out sg13_hv_pmos_RQMCRC_0/S9 vdd sg13_hv_pmos_RQMCRC_0/S9
+ out sg13_hv_pmos_RQMCRC_0/S9 vdd sg13_hv_pmos_RQMCRC_0/S9 out sg13_hv_pmos_RQMCRC_0/S9
+ vdd sg13_hv_pmos_RQMCRC_0/S9 out sg13_hv_pmos_RQMCRC_0/S9 vdd sg13_hv_pmos_RQMCRC_0/S9
+ out sg13_hv_pmos_RQMCRC_0/S9 vdd sg13_hv_pmos_RQMCRC_0/S9 out sg13_hv_pmos_RQMCRC_0/S9
+ vdd sg13_hv_pmos_RQMCRC_0/S9 out sg13_hv_pmos_RQMCRC_0/S9 vdd sg13_hv_pmos_RQMCRC_0/S9
+ out sg13_hv_pmos_RQMCRC_0/S9 vdd sg13_hv_pmos_RQMCRC_0/S9 out sg13_hv_pmos_RQMCRC_0/S9
+ vdd sg13_hv_pmos_RQMCRC_0/S9 out sg13_hv_pmos_RQMCRC_0/S9 vdd vdd sg13_hv_pmos_RQMCRC
.ends

.subckt sg13cmos5l_antennanp A VDD VSS
X0 A VDD dpantenna l=1.34u w=1.05u
X1 VSS A dantenna l=0.78u w=0.78u
.ends

.subckt sg13cmos5l_decap_4 VDD VSS
X0 VDD VSS VDD VDD sg13_lv_pmos ad=0.34p pd=2.68u as=2.4331p ps=11.58u w=1u l=1u
X1 VSS VDD VSS VSS sg13_lv_nmos ad=0.1428p pd=1.52u as=1.84612p ps=9.32u w=0.42u l=1u
.ends

.subckt pmos_waffle_20 B A SUB GATE
X0 A GATE B A sg13_hv_pmos ad=5.4312p pd=15.6u as=3.052p ps=10.12u w=4.36u l=0.4u
X1 A GATE B A sg13_hv_pmos ad=5.4312p pd=15.6u as=3.052p ps=10.12u w=4.36u l=0.4u
X2 B GATE A A sg13_hv_pmos ad=5.4312p pd=15.6u as=5.4312p ps=15.6u w=4.36u l=0.4u
X3 A GATE B A sg13_hv_pmos ad=5.4312p pd=15.6u as=5.4312p ps=15.6u w=4.36u l=0.4u
X4 A GATE B A sg13_hv_pmos ad=5.4312p pd=15.6u as=5.4312p ps=15.6u w=4.36u l=0.4u
X5 B GATE A A sg13_hv_pmos ad=5.4312p pd=15.6u as=5.4312p ps=15.6u w=4.36u l=0.4u
X6 A GATE B A sg13_hv_pmos ad=5.4312p pd=15.6u as=5.4312p ps=15.6u w=4.36u l=0.4u
X7 A GATE B A sg13_hv_pmos ad=5.4312p pd=15.6u as=5.4312p ps=15.6u w=4.36u l=0.4u
X8 B GATE A A sg13_hv_pmos ad=5.4312p pd=15.6u as=5.4312p ps=15.6u w=4.36u l=0.4u
X9 B GATE A A sg13_hv_pmos ad=5.4312p pd=15.6u as=5.4312p ps=15.6u w=4.36u l=0.4u
X10 A GATE B A sg13_hv_pmos ad=5.4312p pd=15.6u as=3.052p ps=10.12u w=4.36u l=0.4u
X11 A GATE B A sg13_hv_pmos ad=5.4312p pd=15.6u as=3.052p ps=10.12u w=4.36u l=0.4u
X12 B GATE A A sg13_hv_pmos ad=5.4312p pd=15.6u as=5.4312p ps=15.6u w=4.36u l=0.4u
X13 A GATE B A sg13_hv_pmos ad=3.052p pd=10.12u as=5.4312p ps=15.6u w=4.36u l=0.4u
X14 A GATE B A sg13_hv_pmos ad=5.4312p pd=15.6u as=5.4312p ps=15.6u w=4.36u l=0.4u
X15 A GATE B A sg13_hv_pmos ad=5.4312p pd=15.6u as=5.4312p ps=15.6u w=4.36u l=0.4u
X16 B GATE A A sg13_hv_pmos ad=5.4312p pd=15.6u as=5.4312p ps=15.6u w=4.36u l=0.4u
X17 B GATE A A sg13_hv_pmos ad=5.4312p pd=15.6u as=3.052p ps=10.12u w=4.36u l=0.4u
X18 B GATE A A sg13_hv_pmos ad=5.4312p pd=15.6u as=5.4312p ps=15.6u w=4.36u l=0.4u
X19 A GATE B A sg13_hv_pmos ad=5.4312p pd=15.6u as=5.4312p ps=15.6u w=4.36u l=0.4u
X20 A GATE B A sg13_hv_pmos ad=5.4312p pd=15.6u as=5.4312p ps=15.6u w=4.36u l=0.4u
X21 B GATE A A sg13_hv_pmos ad=5.4312p pd=15.6u as=5.4312p ps=15.6u w=4.36u l=0.4u
X22 B GATE A A sg13_hv_pmos ad=5.4312p pd=15.6u as=5.4312p ps=15.6u w=4.36u l=0.4u
X23 A GATE B A sg13_hv_pmos ad=5.4312p pd=15.6u as=3.052p ps=10.12u w=4.36u l=0.4u
X24 A GATE B A sg13_hv_pmos ad=5.4312p pd=15.6u as=5.4312p ps=15.6u w=4.36u l=0.4u
X25 A GATE B A sg13_hv_pmos ad=5.4312p pd=15.6u as=5.4312p ps=15.6u w=4.36u l=0.4u
X26 A GATE B A sg13_hv_pmos ad=5.4312p pd=15.6u as=5.4312p ps=15.6u w=4.36u l=0.4u
X27 B GATE A A sg13_hv_pmos ad=3.052p pd=10.12u as=5.4312p ps=15.6u w=4.36u l=0.4u
X28 B GATE A A sg13_hv_pmos ad=5.4312p pd=15.6u as=5.4312p ps=15.6u w=4.36u l=0.4u
X29 B GATE A A sg13_hv_pmos ad=5.4312p pd=15.6u as=5.4312p ps=15.6u w=4.36u l=0.4u
X30 A GATE B A sg13_hv_pmos ad=5.4312p pd=15.6u as=5.4312p ps=15.6u w=4.36u l=0.4u
X31 A GATE B A sg13_hv_pmos ad=5.4312p pd=15.6u as=5.4312p ps=15.6u w=4.36u l=0.4u
X32 B GATE A A sg13_hv_pmos ad=5.4312p pd=15.6u as=5.4312p ps=15.6u w=4.36u l=0.4u
X33 B GATE A A sg13_hv_pmos ad=5.4312p pd=15.6u as=5.4312p ps=15.6u w=4.36u l=0.4u
X34 B GATE A A sg13_hv_pmos ad=5.4312p pd=15.6u as=5.4312p ps=15.6u w=4.36u l=0.4u
X35 A GATE B A sg13_hv_pmos ad=5.4312p pd=15.6u as=5.4312p ps=15.6u w=4.36u l=0.4u
X36 A GATE B A sg13_hv_pmos ad=5.4312p pd=15.6u as=5.4312p ps=15.6u w=4.36u l=0.4u
X37 B GATE A A sg13_hv_pmos ad=5.4312p pd=15.6u as=5.4312p ps=15.6u w=4.36u l=0.4u
X38 A GATE B A sg13_hv_pmos ad=5.4312p pd=15.6u as=5.4312p ps=15.6u w=4.36u l=0.4u
X39 A GATE B A sg13_hv_pmos ad=3.052p pd=10.12u as=5.4312p ps=15.6u w=4.36u l=0.4u
X40 B GATE A A sg13_hv_pmos ad=5.4312p pd=15.6u as=5.4312p ps=15.6u w=4.36u l=0.4u
X41 B GATE A A sg13_hv_pmos ad=5.4312p pd=15.6u as=5.4312p ps=15.6u w=4.36u l=0.4u
X42 A GATE B A sg13_hv_pmos ad=3.052p pd=10.12u as=5.4312p ps=15.6u w=4.36u l=0.4u
X43 B GATE A A sg13_hv_pmos ad=3.052p pd=10.12u as=5.4312p ps=15.6u w=4.36u l=0.4u
X44 A GATE B A sg13_hv_pmos ad=5.4312p pd=15.6u as=5.4312p ps=15.6u w=4.36u l=0.4u
X45 A GATE B A sg13_hv_pmos ad=5.4312p pd=15.6u as=5.4312p ps=15.6u w=4.36u l=0.4u
X46 B GATE A A sg13_hv_pmos ad=5.4312p pd=15.6u as=5.4312p ps=15.6u w=4.36u l=0.4u
X47 A GATE B A sg13_hv_pmos ad=5.4312p pd=15.6u as=5.4312p ps=15.6u w=4.36u l=0.4u
X48 B GATE A A sg13_hv_pmos ad=5.4312p pd=15.6u as=5.4312p ps=15.6u w=4.36u l=0.4u
X49 A GATE B A sg13_hv_pmos ad=5.4312p pd=15.6u as=5.4312p ps=15.6u w=4.36u l=0.4u
X50 B GATE A A sg13_hv_pmos ad=3.052p pd=10.12u as=5.4312p ps=15.6u w=4.36u l=0.4u
X51 B GATE A A sg13_hv_pmos ad=5.4312p pd=15.6u as=5.4312p ps=15.6u w=4.36u l=0.4u
X52 A GATE B A sg13_hv_pmos ad=5.4312p pd=15.6u as=5.4312p ps=15.6u w=4.36u l=0.4u
X53 A GATE B A sg13_hv_pmos ad=5.4312p pd=15.6u as=5.4312p ps=15.6u w=4.36u l=0.4u
X54 A GATE B A sg13_hv_pmos ad=3.052p pd=10.12u as=5.4312p ps=15.6u w=4.36u l=0.4u
X55 B GATE A A sg13_hv_pmos ad=5.4312p pd=15.6u as=5.4312p ps=15.6u w=4.36u l=0.4u
X56 A GATE B A sg13_hv_pmos ad=5.4312p pd=15.6u as=5.4312p ps=15.6u w=4.36u l=0.4u
X57 A GATE B A sg13_hv_pmos ad=5.4312p pd=15.6u as=5.4312p ps=15.6u w=4.36u l=0.4u
X58 B GATE A A sg13_hv_pmos ad=5.4312p pd=15.6u as=5.4312p ps=15.6u w=4.36u l=0.4u
X59 B GATE A A sg13_hv_pmos ad=5.4312p pd=15.6u as=5.4312p ps=15.6u w=4.36u l=0.4u
X60 A GATE B A sg13_hv_pmos ad=5.4312p pd=15.6u as=5.4312p ps=15.6u w=4.36u l=0.4u
X61 A GATE B A sg13_hv_pmos ad=5.4312p pd=15.6u as=3.052p ps=10.12u w=4.36u l=0.4u
X62 B GATE A A sg13_hv_pmos ad=3.052p pd=10.12u as=5.4312p ps=15.6u w=4.36u l=0.4u
X63 A GATE B A sg13_hv_pmos ad=5.4312p pd=15.6u as=5.4312p ps=15.6u w=4.36u l=0.4u
X64 A GATE B A sg13_hv_pmos ad=3.052p pd=10.12u as=5.4312p ps=15.6u w=4.36u l=0.4u
X65 B GATE A A sg13_hv_pmos ad=5.4312p pd=15.6u as=5.4312p ps=15.6u w=4.36u l=0.4u
X66 A GATE B A sg13_hv_pmos ad=5.4312p pd=15.6u as=5.4312p ps=15.6u w=4.36u l=0.4u
X67 B GATE A A sg13_hv_pmos ad=3.052p pd=10.12u as=5.4312p ps=15.6u w=4.36u l=0.4u
X68 A GATE B A sg13_hv_pmos ad=5.4312p pd=15.6u as=5.4312p ps=15.6u w=4.36u l=0.4u
X69 B GATE A A sg13_hv_pmos ad=5.4312p pd=15.6u as=5.4312p ps=15.6u w=4.36u l=0.4u
X70 A GATE B A sg13_hv_pmos ad=5.4312p pd=15.6u as=5.4312p ps=15.6u w=4.36u l=0.4u
X71 A GATE B A sg13_hv_pmos ad=5.4312p pd=15.6u as=5.4312p ps=15.6u w=4.36u l=0.4u
X72 B GATE A A sg13_hv_pmos ad=5.4312p pd=15.6u as=5.4312p ps=15.6u w=4.36u l=0.4u
X73 A GATE B A sg13_hv_pmos ad=5.4312p pd=15.6u as=5.4312p ps=15.6u w=4.36u l=0.4u
X74 B GATE A A sg13_hv_pmos ad=5.4312p pd=15.6u as=5.4312p ps=15.6u w=4.36u l=0.4u
X75 A GATE B A sg13_hv_pmos ad=5.4312p pd=15.6u as=5.4312p ps=15.6u w=4.36u l=0.4u
X76 B GATE A A sg13_hv_pmos ad=5.4312p pd=15.6u as=5.4312p ps=15.6u w=4.36u l=0.4u
X77 A GATE B A sg13_hv_pmos ad=5.4312p pd=15.6u as=5.4312p ps=15.6u w=4.36u l=0.4u
X78 B GATE A A sg13_hv_pmos ad=5.4312p pd=15.6u as=5.4312p ps=15.6u w=4.36u l=0.4u
X79 B GATE A A sg13_hv_pmos ad=3.052p pd=10.12u as=5.4312p ps=15.6u w=4.36u l=0.4u
X80 B GATE A A sg13_hv_pmos ad=5.4312p pd=15.6u as=5.4312p ps=15.6u w=4.36u l=0.4u
X81 A GATE B A sg13_hv_pmos ad=5.4312p pd=15.6u as=5.4312p ps=15.6u w=4.36u l=0.4u
X82 B GATE A A sg13_hv_pmos ad=5.4312p pd=15.6u as=5.4312p ps=15.6u w=4.36u l=0.4u
X83 A GATE B A sg13_hv_pmos ad=5.4312p pd=15.6u as=5.4312p ps=15.6u w=4.36u l=0.4u
X84 A GATE B A sg13_hv_pmos ad=3.052p pd=10.12u as=5.4312p ps=15.6u w=4.36u l=0.4u
X85 B GATE A A sg13_hv_pmos ad=5.4312p pd=15.6u as=3.052p ps=10.12u w=4.36u l=0.4u
X86 A GATE B A sg13_hv_pmos ad=5.4312p pd=15.6u as=5.4312p ps=15.6u w=4.36u l=0.4u
X87 B GATE A A sg13_hv_pmos ad=5.4312p pd=15.6u as=5.4312p ps=15.6u w=4.36u l=0.4u
X88 A GATE B A sg13_hv_pmos ad=5.4312p pd=15.6u as=5.4312p ps=15.6u w=4.36u l=0.4u
X89 B GATE A A sg13_hv_pmos ad=5.4312p pd=15.6u as=5.4312p ps=15.6u w=4.36u l=0.4u
X90 B GATE A A sg13_hv_pmos ad=5.4312p pd=15.6u as=5.4312p ps=15.6u w=4.36u l=0.4u
X91 A GATE B A sg13_hv_pmos ad=5.4312p pd=15.6u as=5.4312p ps=15.6u w=4.36u l=0.4u
X92 B GATE A A sg13_hv_pmos ad=5.4312p pd=15.6u as=5.4312p ps=15.6u w=4.36u l=0.4u
X93 A GATE B A sg13_hv_pmos ad=5.4312p pd=15.6u as=5.4312p ps=15.6u w=4.36u l=0.4u
X94 B GATE A A sg13_hv_pmos ad=5.4312p pd=15.6u as=5.4312p ps=15.6u w=4.36u l=0.4u
X95 A GATE B A sg13_hv_pmos ad=5.4312p pd=15.6u as=5.4312p ps=15.6u w=4.36u l=0.4u
X96 A GATE B A sg13_hv_pmos ad=3.052p pd=10.12u as=5.4312p ps=15.6u w=4.36u l=0.4u
X97 A GATE B A sg13_hv_pmos ad=5.4312p pd=15.6u as=5.4312p ps=15.6u w=4.36u l=0.4u
X98 B GATE A A sg13_hv_pmos ad=5.4312p pd=15.6u as=5.4312p ps=15.6u w=4.36u l=0.4u
X99 B GATE A A sg13_hv_pmos ad=3.052p pd=10.12u as=5.4312p ps=15.6u w=4.36u l=0.4u
X100 A GATE B A sg13_hv_pmos ad=5.4312p pd=15.6u as=5.4312p ps=15.6u w=4.36u l=0.4u
X101 B GATE A A sg13_hv_pmos ad=5.4312p pd=15.6u as=5.4312p ps=15.6u w=4.36u l=0.4u
X102 A GATE B A sg13_hv_pmos ad=5.4312p pd=15.6u as=5.4312p ps=15.6u w=4.36u l=0.4u
X103 B GATE A A sg13_hv_pmos ad=5.4312p pd=15.6u as=5.4312p ps=15.6u w=4.36u l=0.4u
X104 A GATE B A sg13_hv_pmos ad=5.4312p pd=15.6u as=5.4312p ps=15.6u w=4.36u l=0.4u
X105 A GATE B A sg13_hv_pmos ad=5.4312p pd=15.6u as=5.4312p ps=15.6u w=4.36u l=0.4u
X106 A GATE B A sg13_hv_pmos ad=5.4312p pd=15.6u as=5.4312p ps=15.6u w=4.36u l=0.4u
X107 B GATE A A sg13_hv_pmos ad=5.4312p pd=15.6u as=5.4312p ps=15.6u w=4.36u l=0.4u
X108 A GATE B A sg13_hv_pmos ad=5.4312p pd=15.6u as=5.4312p ps=15.6u w=4.36u l=0.4u
X109 B GATE A A sg13_hv_pmos ad=5.4312p pd=15.6u as=5.4312p ps=15.6u w=4.36u l=0.4u
X110 B GATE A A sg13_hv_pmos ad=5.4312p pd=15.6u as=5.4312p ps=15.6u w=4.36u l=0.4u
X111 A GATE B A sg13_hv_pmos ad=5.4312p pd=15.6u as=3.052p ps=10.12u w=4.36u l=0.4u
X112 A GATE B A sg13_hv_pmos ad=3.052p pd=10.12u as=5.4312p ps=15.6u w=4.36u l=0.4u
X113 B GATE A A sg13_hv_pmos ad=5.4312p pd=15.6u as=5.4312p ps=15.6u w=4.36u l=0.4u
X114 B GATE A A sg13_hv_pmos ad=3.052p pd=10.12u as=5.4312p ps=15.6u w=4.36u l=0.4u
X115 A GATE B A sg13_hv_pmos ad=5.4312p pd=15.6u as=5.4312p ps=15.6u w=4.36u l=0.4u
X116 B GATE A A sg13_hv_pmos ad=5.4312p pd=15.6u as=5.4312p ps=15.6u w=4.36u l=0.4u
X117 A GATE B A sg13_hv_pmos ad=5.4312p pd=15.6u as=5.4312p ps=15.6u w=4.36u l=0.4u
X118 A GATE B A sg13_hv_pmos ad=5.4312p pd=15.6u as=5.4312p ps=15.6u w=4.36u l=0.4u
X119 A GATE B A sg13_hv_pmos ad=3.052p pd=10.12u as=5.4312p ps=15.6u w=4.36u l=0.4u
X120 A GATE B A sg13_hv_pmos ad=5.4312p pd=15.6u as=5.4312p ps=15.6u w=4.36u l=0.4u
X121 B GATE A A sg13_hv_pmos ad=5.4312p pd=15.6u as=5.4312p ps=15.6u w=4.36u l=0.4u
X122 B GATE A A sg13_hv_pmos ad=5.4312p pd=15.6u as=5.4312p ps=15.6u w=4.36u l=0.4u
X123 B GATE A A sg13_hv_pmos ad=5.4312p pd=15.6u as=5.4312p ps=15.6u w=4.36u l=0.4u
X124 B GATE A A sg13_hv_pmos ad=5.4312p pd=15.6u as=5.4312p ps=15.6u w=4.36u l=0.4u
X125 B GATE A A sg13_hv_pmos ad=5.4312p pd=15.6u as=5.4312p ps=15.6u w=4.36u l=0.4u
X126 A GATE B A sg13_hv_pmos ad=5.4312p pd=15.6u as=5.4312p ps=15.6u w=4.36u l=0.4u
X127 A GATE B A sg13_hv_pmos ad=5.4312p pd=15.6u as=5.4312p ps=15.6u w=4.36u l=0.4u
X128 A GATE B A sg13_hv_pmos ad=5.4312p pd=15.6u as=5.4312p ps=15.6u w=4.36u l=0.4u
X129 A GATE B A sg13_hv_pmos ad=5.4312p pd=15.6u as=5.4312p ps=15.6u w=4.36u l=0.4u
X130 A GATE B A sg13_hv_pmos ad=3.052p pd=10.12u as=5.4312p ps=15.6u w=4.36u l=0.4u
X131 B GATE A A sg13_hv_pmos ad=5.4312p pd=15.6u as=5.4312p ps=15.6u w=4.36u l=0.4u
X132 A GATE B A sg13_hv_pmos ad=5.4312p pd=15.6u as=5.4312p ps=15.6u w=4.36u l=0.4u
X133 B GATE A A sg13_hv_pmos ad=5.4312p pd=15.6u as=5.4312p ps=15.6u w=4.36u l=0.4u
X134 B GATE A A sg13_hv_pmos ad=5.4312p pd=15.6u as=5.4312p ps=15.6u w=4.36u l=0.4u
X135 B GATE A A sg13_hv_pmos ad=5.4312p pd=15.6u as=5.4312p ps=15.6u w=4.36u l=0.4u
X136 B GATE A A sg13_hv_pmos ad=3.052p pd=10.12u as=5.4312p ps=15.6u w=4.36u l=0.4u
X137 A GATE B A sg13_hv_pmos ad=5.4312p pd=15.6u as=5.4312p ps=15.6u w=4.36u l=0.4u
X138 B GATE A A sg13_hv_pmos ad=5.4312p pd=15.6u as=5.4312p ps=15.6u w=4.36u l=0.4u
X139 A GATE B A sg13_hv_pmos ad=5.4312p pd=15.6u as=5.4312p ps=15.6u w=4.36u l=0.4u
X140 A GATE B A sg13_hv_pmos ad=5.4312p pd=15.6u as=5.4312p ps=15.6u w=4.36u l=0.4u
X141 B GATE A A sg13_hv_pmos ad=5.4312p pd=15.6u as=3.052p ps=10.12u w=4.36u l=0.4u
X142 A GATE B A sg13_hv_pmos ad=5.4312p pd=15.6u as=5.4312p ps=15.6u w=4.36u l=0.4u
X143 A GATE B A sg13_hv_pmos ad=5.4312p pd=15.6u as=5.4312p ps=15.6u w=4.36u l=0.4u
X144 B GATE A A sg13_hv_pmos ad=5.4312p pd=15.6u as=5.4312p ps=15.6u w=4.36u l=0.4u
X145 B GATE A A sg13_hv_pmos ad=5.4312p pd=15.6u as=3.052p ps=10.12u w=4.36u l=0.4u
X146 A GATE B A sg13_hv_pmos ad=5.4312p pd=15.6u as=5.4312p ps=15.6u w=4.36u l=0.4u
X147 B GATE A A sg13_hv_pmos ad=5.4312p pd=15.6u as=5.4312p ps=15.6u w=4.36u l=0.4u
X148 B GATE A A sg13_hv_pmos ad=5.4312p pd=15.6u as=5.4312p ps=15.6u w=4.36u l=0.4u
X149 B GATE A A sg13_hv_pmos ad=5.4312p pd=15.6u as=5.4312p ps=15.6u w=4.36u l=0.4u
X150 B GATE A A sg13_hv_pmos ad=5.4312p pd=15.6u as=5.4312p ps=15.6u w=4.36u l=0.4u
X151 A GATE B A sg13_hv_pmos ad=5.4312p pd=15.6u as=5.4312p ps=15.6u w=4.36u l=0.4u
X152 B GATE A A sg13_hv_pmos ad=3.052p pd=10.12u as=5.4312p ps=15.6u w=4.36u l=0.4u
X153 A GATE B A sg13_hv_pmos ad=5.4312p pd=15.6u as=5.4312p ps=15.6u w=4.36u l=0.4u
X154 A GATE B A sg13_hv_pmos ad=5.4312p pd=15.6u as=5.4312p ps=15.6u w=4.36u l=0.4u
X155 A GATE B A sg13_hv_pmos ad=5.4312p pd=15.6u as=5.4312p ps=15.6u w=4.36u l=0.4u
X156 B GATE A A sg13_hv_pmos ad=5.4312p pd=15.6u as=5.4312p ps=15.6u w=4.36u l=0.4u
X157 A GATE B A sg13_hv_pmos ad=3.052p pd=10.12u as=5.4312p ps=15.6u w=4.36u l=0.4u
X158 A GATE B A sg13_hv_pmos ad=5.4312p pd=15.6u as=5.4312p ps=15.6u w=4.36u l=0.4u
X159 B GATE A A sg13_hv_pmos ad=5.4312p pd=15.6u as=5.4312p ps=15.6u w=4.36u l=0.4u
X160 B GATE A A sg13_hv_pmos ad=5.4312p pd=15.6u as=5.4312p ps=15.6u w=4.36u l=0.4u
X161 B GATE A A sg13_hv_pmos ad=5.4312p pd=15.6u as=5.4312p ps=15.6u w=4.36u l=0.4u
X162 B GATE A A sg13_hv_pmos ad=5.4312p pd=15.6u as=5.4312p ps=15.6u w=4.36u l=0.4u
X163 B GATE A A sg13_hv_pmos ad=5.4312p pd=15.6u as=5.4312p ps=15.6u w=4.36u l=0.4u
X164 A GATE B A sg13_hv_pmos ad=5.4312p pd=15.6u as=5.4312p ps=15.6u w=4.36u l=0.4u
X165 A GATE B A sg13_hv_pmos ad=5.4312p pd=15.6u as=5.4312p ps=15.6u w=4.36u l=0.4u
X166 A GATE B A sg13_hv_pmos ad=5.4312p pd=15.6u as=5.4312p ps=15.6u w=4.36u l=0.4u
X167 A GATE B A sg13_hv_pmos ad=5.4312p pd=15.6u as=5.4312p ps=15.6u w=4.36u l=0.4u
X168 B GATE A A sg13_hv_pmos ad=5.4312p pd=15.6u as=3.052p ps=10.12u w=4.36u l=0.4u
X169 B GATE A A sg13_hv_pmos ad=5.4312p pd=15.6u as=3.052p ps=10.12u w=4.36u l=0.4u
X170 A GATE B A sg13_hv_pmos ad=5.4312p pd=15.6u as=5.4312p ps=15.6u w=4.36u l=0.4u
X171 B GATE A A sg13_hv_pmos ad=5.4312p pd=15.6u as=5.4312p ps=15.6u w=4.36u l=0.4u
X172 B GATE A A sg13_hv_pmos ad=5.4312p pd=15.6u as=5.4312p ps=15.6u w=4.36u l=0.4u
X173 A GATE B A sg13_hv_pmos ad=3.052p pd=10.12u as=5.4312p ps=15.6u w=4.36u l=0.4u
X174 B GATE A A sg13_hv_pmos ad=5.4312p pd=15.6u as=5.4312p ps=15.6u w=4.36u l=0.4u
X175 A GATE B A sg13_hv_pmos ad=5.4312p pd=15.6u as=5.4312p ps=15.6u w=4.36u l=0.4u
X176 A GATE B A sg13_hv_pmos ad=5.4312p pd=15.6u as=3.052p ps=10.12u w=4.36u l=0.4u
X177 B GATE A A sg13_hv_pmos ad=5.4312p pd=15.6u as=5.4312p ps=15.6u w=4.36u l=0.4u
X178 A GATE B A sg13_hv_pmos ad=5.4312p pd=15.6u as=5.4312p ps=15.6u w=4.36u l=0.4u
X179 B GATE A A sg13_hv_pmos ad=5.4312p pd=15.6u as=5.4312p ps=15.6u w=4.36u l=0.4u
X180 B GATE A A sg13_hv_pmos ad=3.052p pd=10.12u as=5.4312p ps=15.6u w=4.36u l=0.4u
X181 A GATE B A sg13_hv_pmos ad=5.4312p pd=15.6u as=5.4312p ps=15.6u w=4.36u l=0.4u
X182 B GATE A A sg13_hv_pmos ad=5.4312p pd=15.6u as=5.4312p ps=15.6u w=4.36u l=0.4u
X183 A GATE B A sg13_hv_pmos ad=5.4312p pd=15.6u as=5.4312p ps=15.6u w=4.36u l=0.4u
X184 A GATE B A sg13_hv_pmos ad=5.4312p pd=15.6u as=5.4312p ps=15.6u w=4.36u l=0.4u
X185 A GATE B A sg13_hv_pmos ad=5.4312p pd=15.6u as=5.4312p ps=15.6u w=4.36u l=0.4u
X186 B GATE A A sg13_hv_pmos ad=5.4312p pd=15.6u as=5.4312p ps=15.6u w=4.36u l=0.4u
X187 A GATE B A sg13_hv_pmos ad=5.4312p pd=15.6u as=5.4312p ps=15.6u w=4.36u l=0.4u
X188 B GATE A A sg13_hv_pmos ad=5.4312p pd=15.6u as=5.4312p ps=15.6u w=4.36u l=0.4u
X189 B GATE A A sg13_hv_pmos ad=5.4312p pd=15.6u as=5.4312p ps=15.6u w=4.36u l=0.4u
X190 B GATE A A sg13_hv_pmos ad=5.4312p pd=15.6u as=5.4312p ps=15.6u w=4.36u l=0.4u
X191 A GATE B A sg13_hv_pmos ad=5.4312p pd=15.6u as=5.4312p ps=15.6u w=4.36u l=0.4u
X192 B GATE A A sg13_hv_pmos ad=5.4312p pd=15.6u as=5.4312p ps=15.6u w=4.36u l=0.4u
X193 B GATE A A sg13_hv_pmos ad=5.4312p pd=15.6u as=5.4312p ps=15.6u w=4.36u l=0.4u
X194 A GATE B A sg13_hv_pmos ad=5.4312p pd=15.6u as=5.4312p ps=15.6u w=4.36u l=0.4u
X195 A GATE B A sg13_hv_pmos ad=5.4312p pd=15.6u as=5.4312p ps=15.6u w=4.36u l=0.4u
X196 A GATE B A sg13_hv_pmos ad=5.4312p pd=15.6u as=5.4312p ps=15.6u w=4.36u l=0.4u
X197 B GATE A A sg13_hv_pmos ad=5.4312p pd=15.6u as=3.052p ps=10.12u w=4.36u l=0.4u
X198 A GATE B A sg13_hv_pmos ad=5.4312p pd=15.6u as=5.4312p ps=15.6u w=4.36u l=0.4u
X199 B GATE A A sg13_hv_pmos ad=5.4312p pd=15.6u as=5.4312p ps=15.6u w=4.36u l=0.4u
X200 A GATE B A sg13_hv_pmos ad=5.4312p pd=15.6u as=5.4312p ps=15.6u w=4.36u l=0.4u
X201 B GATE A A sg13_hv_pmos ad=5.4312p pd=15.6u as=5.4312p ps=15.6u w=4.36u l=0.4u
X202 B GATE A A sg13_hv_pmos ad=5.4312p pd=15.6u as=5.4312p ps=15.6u w=4.36u l=0.4u
X203 B GATE A A sg13_hv_pmos ad=5.4312p pd=15.6u as=5.4312p ps=15.6u w=4.36u l=0.4u
X204 A GATE B A sg13_hv_pmos ad=5.4312p pd=15.6u as=5.4312p ps=15.6u w=4.36u l=0.4u
X205 B GATE A A sg13_hv_pmos ad=5.4312p pd=15.6u as=5.4312p ps=15.6u w=4.36u l=0.4u
X206 B GATE A A sg13_hv_pmos ad=5.4312p pd=15.6u as=5.4312p ps=15.6u w=4.36u l=0.4u
X207 A GATE B A sg13_hv_pmos ad=5.4312p pd=15.6u as=5.4312p ps=15.6u w=4.36u l=0.4u
X208 A GATE B A sg13_hv_pmos ad=5.4312p pd=15.6u as=5.4312p ps=15.6u w=4.36u l=0.4u
X209 A GATE B A sg13_hv_pmos ad=5.4312p pd=15.6u as=5.4312p ps=15.6u w=4.36u l=0.4u
X210 B GATE A A sg13_hv_pmos ad=5.4312p pd=15.6u as=3.052p ps=10.12u w=4.36u l=0.4u
X211 A GATE B A sg13_hv_pmos ad=5.4312p pd=15.6u as=5.4312p ps=15.6u w=4.36u l=0.4u
X212 B GATE A A sg13_hv_pmos ad=5.4312p pd=15.6u as=5.4312p ps=15.6u w=4.36u l=0.4u
X213 A GATE B A sg13_hv_pmos ad=5.4312p pd=15.6u as=5.4312p ps=15.6u w=4.36u l=0.4u
X214 A GATE B A sg13_hv_pmos ad=5.4312p pd=15.6u as=5.4312p ps=15.6u w=4.36u l=0.4u
X215 B GATE A A sg13_hv_pmos ad=5.4312p pd=15.6u as=5.4312p ps=15.6u w=4.36u l=0.4u
X216 B GATE A A sg13_hv_pmos ad=5.4312p pd=15.6u as=5.4312p ps=15.6u w=4.36u l=0.4u
X217 B GATE A A sg13_hv_pmos ad=5.4312p pd=15.6u as=5.4312p ps=15.6u w=4.36u l=0.4u
X218 B GATE A A sg13_hv_pmos ad=5.4312p pd=15.6u as=5.4312p ps=15.6u w=4.36u l=0.4u
X219 B GATE A A sg13_hv_pmos ad=5.4312p pd=15.6u as=5.4312p ps=15.6u w=4.36u l=0.4u
X220 A GATE B A sg13_hv_pmos ad=5.4312p pd=15.6u as=5.4312p ps=15.6u w=4.36u l=0.4u
X221 B GATE A A sg13_hv_pmos ad=5.4312p pd=15.6u as=5.4312p ps=15.6u w=4.36u l=0.4u
X222 A GATE B A sg13_hv_pmos ad=5.4312p pd=15.6u as=5.4312p ps=15.6u w=4.36u l=0.4u
X223 A GATE B A sg13_hv_pmos ad=5.4312p pd=15.6u as=5.4312p ps=15.6u w=4.36u l=0.4u
X224 A GATE B A sg13_hv_pmos ad=5.4312p pd=15.6u as=5.4312p ps=15.6u w=4.36u l=0.4u
X225 A GATE B A sg13_hv_pmos ad=5.4312p pd=15.6u as=5.4312p ps=15.6u w=4.36u l=0.4u
X226 A GATE B A sg13_hv_pmos ad=5.4312p pd=15.6u as=5.4312p ps=15.6u w=4.36u l=0.4u
X227 B GATE A A sg13_hv_pmos ad=5.4312p pd=15.6u as=5.4312p ps=15.6u w=4.36u l=0.4u
X228 B GATE A A sg13_hv_pmos ad=5.4312p pd=15.6u as=5.4312p ps=15.6u w=4.36u l=0.4u
X229 B GATE A A sg13_hv_pmos ad=5.4312p pd=15.6u as=5.4312p ps=15.6u w=4.36u l=0.4u
X230 B GATE A A sg13_hv_pmos ad=5.4312p pd=15.6u as=5.4312p ps=15.6u w=4.36u l=0.4u
X231 B GATE A A sg13_hv_pmos ad=5.4312p pd=15.6u as=5.4312p ps=15.6u w=4.36u l=0.4u
X232 A GATE B A sg13_hv_pmos ad=5.4312p pd=15.6u as=5.4312p ps=15.6u w=4.36u l=0.4u
X233 B GATE A A sg13_hv_pmos ad=5.4312p pd=15.6u as=5.4312p ps=15.6u w=4.36u l=0.4u
X234 A GATE B A sg13_hv_pmos ad=5.4312p pd=15.6u as=5.4312p ps=15.6u w=4.36u l=0.4u
X235 A GATE B A sg13_hv_pmos ad=5.4312p pd=15.6u as=5.4312p ps=15.6u w=4.36u l=0.4u
X236 A GATE B A sg13_hv_pmos ad=5.4312p pd=15.6u as=5.4312p ps=15.6u w=4.36u l=0.4u
X237 B GATE A A sg13_hv_pmos ad=5.4312p pd=15.6u as=5.4312p ps=15.6u w=4.36u l=0.4u
X238 A GATE B A sg13_hv_pmos ad=5.4312p pd=15.6u as=5.4312p ps=15.6u w=4.36u l=0.4u
X239 B GATE A A sg13_hv_pmos ad=5.4312p pd=15.6u as=5.4312p ps=15.6u w=4.36u l=0.4u
X240 B GATE A A sg13_hv_pmos ad=5.4312p pd=15.6u as=5.4312p ps=15.6u w=4.36u l=0.4u
X241 A GATE B A sg13_hv_pmos ad=5.4312p pd=15.6u as=5.4312p ps=15.6u w=4.36u l=0.4u
X242 B GATE A A sg13_hv_pmos ad=5.4312p pd=15.6u as=5.4312p ps=15.6u w=4.36u l=0.4u
X243 A GATE B A sg13_hv_pmos ad=5.4312p pd=15.6u as=3.052p ps=10.12u w=4.36u l=0.4u
X244 B GATE A A sg13_hv_pmos ad=5.4312p pd=15.6u as=5.4312p ps=15.6u w=4.36u l=0.4u
X245 A GATE B A sg13_hv_pmos ad=5.4312p pd=15.6u as=5.4312p ps=15.6u w=4.36u l=0.4u
X246 B GATE A A sg13_hv_pmos ad=5.4312p pd=15.6u as=5.4312p ps=15.6u w=4.36u l=0.4u
X247 A GATE B A sg13_hv_pmos ad=5.4312p pd=15.6u as=5.4312p ps=15.6u w=4.36u l=0.4u
X248 B GATE A A sg13_hv_pmos ad=5.4312p pd=15.6u as=5.4312p ps=15.6u w=4.36u l=0.4u
X249 A GATE B A sg13_hv_pmos ad=5.4312p pd=15.6u as=5.4312p ps=15.6u w=4.36u l=0.4u
X250 A GATE B A sg13_hv_pmos ad=5.4312p pd=15.6u as=5.4312p ps=15.6u w=4.36u l=0.4u
X251 A GATE B A sg13_hv_pmos ad=5.4312p pd=15.6u as=5.4312p ps=15.6u w=4.36u l=0.4u
X252 A GATE B A sg13_hv_pmos ad=5.4312p pd=15.6u as=5.4312p ps=15.6u w=4.36u l=0.4u
X253 B GATE A A sg13_hv_pmos ad=5.4312p pd=15.6u as=5.4312p ps=15.6u w=4.36u l=0.4u
X254 A GATE B A sg13_hv_pmos ad=5.4312p pd=15.6u as=5.4312p ps=15.6u w=4.36u l=0.4u
X255 B GATE A A sg13_hv_pmos ad=5.4312p pd=15.6u as=5.4312p ps=15.6u w=4.36u l=0.4u
X256 B GATE A A sg13_hv_pmos ad=5.4312p pd=15.6u as=5.4312p ps=15.6u w=4.36u l=0.4u
X257 B GATE A A sg13_hv_pmos ad=5.4312p pd=15.6u as=5.4312p ps=15.6u w=4.36u l=0.4u
X258 B GATE A A sg13_hv_pmos ad=5.4312p pd=15.6u as=5.4312p ps=15.6u w=4.36u l=0.4u
X259 B GATE A A sg13_hv_pmos ad=5.4312p pd=15.6u as=5.4312p ps=15.6u w=4.36u l=0.4u
X260 B GATE A A sg13_hv_pmos ad=5.4312p pd=15.6u as=5.4312p ps=15.6u w=4.36u l=0.4u
X261 A GATE B A sg13_hv_pmos ad=5.4312p pd=15.6u as=5.4312p ps=15.6u w=4.36u l=0.4u
X262 A GATE B A sg13_hv_pmos ad=5.4312p pd=15.6u as=5.4312p ps=15.6u w=4.36u l=0.4u
X263 A GATE B A sg13_hv_pmos ad=5.4312p pd=15.6u as=5.4312p ps=15.6u w=4.36u l=0.4u
X264 A GATE B A sg13_hv_pmos ad=5.4312p pd=15.6u as=5.4312p ps=15.6u w=4.36u l=0.4u
X265 A GATE B A sg13_hv_pmos ad=5.4312p pd=15.6u as=5.4312p ps=15.6u w=4.36u l=0.4u
X266 B GATE A A sg13_hv_pmos ad=5.4312p pd=15.6u as=5.4312p ps=15.6u w=4.36u l=0.4u
X267 A GATE B A sg13_hv_pmos ad=5.4312p pd=15.6u as=5.4312p ps=15.6u w=4.36u l=0.4u
X268 B GATE A A sg13_hv_pmos ad=5.4312p pd=15.6u as=5.4312p ps=15.6u w=4.36u l=0.4u
X269 B GATE A A sg13_hv_pmos ad=5.4312p pd=15.6u as=5.4312p ps=15.6u w=4.36u l=0.4u
X270 B GATE A A sg13_hv_pmos ad=5.4312p pd=15.6u as=5.4312p ps=15.6u w=4.36u l=0.4u
X271 A GATE B A sg13_hv_pmos ad=5.4312p pd=15.6u as=5.4312p ps=15.6u w=4.36u l=0.4u
X272 B GATE A A sg13_hv_pmos ad=5.4312p pd=15.6u as=5.4312p ps=15.6u w=4.36u l=0.4u
X273 A GATE B A sg13_hv_pmos ad=3.052p pd=10.12u as=5.4312p ps=15.6u w=4.36u l=0.4u
X274 A GATE B A sg13_hv_pmos ad=5.4312p pd=15.6u as=5.4312p ps=15.6u w=4.36u l=0.4u
X275 A GATE B A sg13_hv_pmos ad=5.4312p pd=15.6u as=5.4312p ps=15.6u w=4.36u l=0.4u
X276 B GATE A A sg13_hv_pmos ad=5.4312p pd=15.6u as=5.4312p ps=15.6u w=4.36u l=0.4u
X277 A GATE B A sg13_hv_pmos ad=5.4312p pd=15.6u as=5.4312p ps=15.6u w=4.36u l=0.4u
X278 B GATE A A sg13_hv_pmos ad=5.4312p pd=15.6u as=3.052p ps=10.12u w=4.36u l=0.4u
X279 A GATE B A sg13_hv_pmos ad=5.4312p pd=15.6u as=5.4312p ps=15.6u w=4.36u l=0.4u
X280 B GATE A A sg13_hv_pmos ad=5.4312p pd=15.6u as=5.4312p ps=15.6u w=4.36u l=0.4u
X281 A GATE B A sg13_hv_pmos ad=5.4312p pd=15.6u as=5.4312p ps=15.6u w=4.36u l=0.4u
X282 B GATE A A sg13_hv_pmos ad=5.4312p pd=15.6u as=5.4312p ps=15.6u w=4.36u l=0.4u
X283 A GATE B A sg13_hv_pmos ad=5.4312p pd=15.6u as=5.4312p ps=15.6u w=4.36u l=0.4u
X284 B GATE A A sg13_hv_pmos ad=5.4312p pd=15.6u as=5.4312p ps=15.6u w=4.36u l=0.4u
X285 B GATE A A sg13_hv_pmos ad=5.4312p pd=15.6u as=5.4312p ps=15.6u w=4.36u l=0.4u
X286 B GATE A A sg13_hv_pmos ad=5.4312p pd=15.6u as=5.4312p ps=15.6u w=4.36u l=0.4u
X287 B GATE A A sg13_hv_pmos ad=5.4312p pd=15.6u as=5.4312p ps=15.6u w=4.36u l=0.4u
X288 B GATE A A sg13_hv_pmos ad=5.4312p pd=15.6u as=5.4312p ps=15.6u w=4.36u l=0.4u
X289 B GATE A A sg13_hv_pmos ad=5.4312p pd=15.6u as=5.4312p ps=15.6u w=4.36u l=0.4u
X290 A GATE B A sg13_hv_pmos ad=5.4312p pd=15.6u as=5.4312p ps=15.6u w=4.36u l=0.4u
X291 B GATE A A sg13_hv_pmos ad=5.4312p pd=15.6u as=5.4312p ps=15.6u w=4.36u l=0.4u
X292 A GATE B A sg13_hv_pmos ad=5.4312p pd=15.6u as=5.4312p ps=15.6u w=4.36u l=0.4u
X293 A GATE B A sg13_hv_pmos ad=5.4312p pd=15.6u as=5.4312p ps=15.6u w=4.36u l=0.4u
X294 B GATE A A sg13_hv_pmos ad=5.4312p pd=15.6u as=5.4312p ps=15.6u w=4.36u l=0.4u
X295 A GATE B A sg13_hv_pmos ad=5.4312p pd=15.6u as=5.4312p ps=15.6u w=4.36u l=0.4u
X296 B GATE A A sg13_hv_pmos ad=5.4312p pd=15.6u as=5.4312p ps=15.6u w=4.36u l=0.4u
X297 A GATE B A sg13_hv_pmos ad=5.4312p pd=15.6u as=5.4312p ps=15.6u w=4.36u l=0.4u
X298 B GATE A A sg13_hv_pmos ad=5.4312p pd=15.6u as=5.4312p ps=15.6u w=4.36u l=0.4u
X299 A GATE B A sg13_hv_pmos ad=5.4312p pd=15.6u as=5.4312p ps=15.6u w=4.36u l=0.4u
X300 B GATE A A sg13_hv_pmos ad=5.4312p pd=15.6u as=5.4312p ps=15.6u w=4.36u l=0.4u
X301 B GATE A A sg13_hv_pmos ad=5.4312p pd=15.6u as=5.4312p ps=15.6u w=4.36u l=0.4u
X302 B GATE A A sg13_hv_pmos ad=5.4312p pd=15.6u as=5.4312p ps=15.6u w=4.36u l=0.4u
X303 A GATE B A sg13_hv_pmos ad=5.4312p pd=15.6u as=5.4312p ps=15.6u w=4.36u l=0.4u
X304 A GATE B A sg13_hv_pmos ad=5.4312p pd=15.6u as=5.4312p ps=15.6u w=4.36u l=0.4u
X305 A GATE B A sg13_hv_pmos ad=5.4312p pd=15.6u as=5.4312p ps=15.6u w=4.36u l=0.4u
X306 A GATE B A sg13_hv_pmos ad=5.4312p pd=15.6u as=5.4312p ps=15.6u w=4.36u l=0.4u
X307 B GATE A A sg13_hv_pmos ad=5.4312p pd=15.6u as=5.4312p ps=15.6u w=4.36u l=0.4u
X308 A GATE B A sg13_hv_pmos ad=5.4312p pd=15.6u as=5.4312p ps=15.6u w=4.36u l=0.4u
X309 B GATE A A sg13_hv_pmos ad=5.4312p pd=15.6u as=5.4312p ps=15.6u w=4.36u l=0.4u
X310 B GATE A A sg13_hv_pmos ad=5.4312p pd=15.6u as=5.4312p ps=15.6u w=4.36u l=0.4u
X311 B GATE A A sg13_hv_pmos ad=5.4312p pd=15.6u as=5.4312p ps=15.6u w=4.36u l=0.4u
X312 A GATE B A sg13_hv_pmos ad=5.4312p pd=15.6u as=5.4312p ps=15.6u w=4.36u l=0.4u
X313 B GATE A A sg13_hv_pmos ad=5.4312p pd=15.6u as=5.4312p ps=15.6u w=4.36u l=0.4u
X314 A GATE B A sg13_hv_pmos ad=5.4312p pd=15.6u as=3.052p ps=10.12u w=4.36u l=0.4u
X315 A GATE B A sg13_hv_pmos ad=5.4312p pd=15.6u as=5.4312p ps=15.6u w=4.36u l=0.4u
X316 B GATE A A sg13_hv_pmos ad=5.4312p pd=15.6u as=5.4312p ps=15.6u w=4.36u l=0.4u
X317 A GATE B A sg13_hv_pmos ad=5.4312p pd=15.6u as=5.4312p ps=15.6u w=4.36u l=0.4u
X318 B GATE A A sg13_hv_pmos ad=5.4312p pd=15.6u as=5.4312p ps=15.6u w=4.36u l=0.4u
X319 B GATE A A sg13_hv_pmos ad=5.4312p pd=15.6u as=5.4312p ps=15.6u w=4.36u l=0.4u
X320 B GATE A A sg13_hv_pmos ad=5.4312p pd=15.6u as=5.4312p ps=15.6u w=4.36u l=0.4u
X321 A GATE B A sg13_hv_pmos ad=5.4312p pd=15.6u as=5.4312p ps=15.6u w=4.36u l=0.4u
X322 A GATE B A sg13_hv_pmos ad=5.4312p pd=15.6u as=5.4312p ps=15.6u w=4.36u l=0.4u
X323 A GATE B A sg13_hv_pmos ad=5.4312p pd=15.6u as=5.4312p ps=15.6u w=4.36u l=0.4u
X324 B GATE A A sg13_hv_pmos ad=5.4312p pd=15.6u as=5.4312p ps=15.6u w=4.36u l=0.4u
X325 A GATE B A sg13_hv_pmos ad=5.4312p pd=15.6u as=5.4312p ps=15.6u w=4.36u l=0.4u
X326 A GATE B A sg13_hv_pmos ad=5.4312p pd=15.6u as=5.4312p ps=15.6u w=4.36u l=0.4u
X327 B GATE A A sg13_hv_pmos ad=5.4312p pd=15.6u as=5.4312p ps=15.6u w=4.36u l=0.4u
X328 A GATE B A sg13_hv_pmos ad=5.4312p pd=15.6u as=5.4312p ps=15.6u w=4.36u l=0.4u
X329 B GATE A A sg13_hv_pmos ad=5.4312p pd=15.6u as=5.4312p ps=15.6u w=4.36u l=0.4u
X330 B GATE A A sg13_hv_pmos ad=5.4312p pd=15.6u as=5.4312p ps=15.6u w=4.36u l=0.4u
X331 A GATE B A sg13_hv_pmos ad=5.4312p pd=15.6u as=5.4312p ps=15.6u w=4.36u l=0.4u
X332 B GATE A A sg13_hv_pmos ad=5.4312p pd=15.6u as=5.4312p ps=15.6u w=4.36u l=0.4u
X333 A GATE B A sg13_hv_pmos ad=5.4312p pd=15.6u as=5.4312p ps=15.6u w=4.36u l=0.4u
X334 B GATE A A sg13_hv_pmos ad=5.4312p pd=15.6u as=5.4312p ps=15.6u w=4.36u l=0.4u
X335 A GATE B A sg13_hv_pmos ad=5.4312p pd=15.6u as=5.4312p ps=15.6u w=4.36u l=0.4u
X336 A GATE B A sg13_hv_pmos ad=5.4312p pd=15.6u as=5.4312p ps=15.6u w=4.36u l=0.4u
X337 A GATE B A sg13_hv_pmos ad=5.4312p pd=15.6u as=5.4312p ps=15.6u w=4.36u l=0.4u
X338 B GATE A A sg13_hv_pmos ad=5.4312p pd=15.6u as=5.4312p ps=15.6u w=4.36u l=0.4u
X339 A GATE B A sg13_hv_pmos ad=3.052p pd=10.12u as=5.4312p ps=15.6u w=4.36u l=0.4u
X340 B GATE A A sg13_hv_pmos ad=5.4312p pd=15.6u as=5.4312p ps=15.6u w=4.36u l=0.4u
X341 B GATE A A sg13_hv_pmos ad=5.4312p pd=15.6u as=5.4312p ps=15.6u w=4.36u l=0.4u
X342 B GATE A A sg13_hv_pmos ad=5.4312p pd=15.6u as=5.4312p ps=15.6u w=4.36u l=0.4u
X343 A GATE B A sg13_hv_pmos ad=5.4312p pd=15.6u as=5.4312p ps=15.6u w=4.36u l=0.4u
X344 A GATE B A sg13_hv_pmos ad=5.4312p pd=15.6u as=5.4312p ps=15.6u w=4.36u l=0.4u
X345 B GATE A A sg13_hv_pmos ad=5.4312p pd=15.6u as=5.4312p ps=15.6u w=4.36u l=0.4u
X346 B GATE A A sg13_hv_pmos ad=5.4312p pd=15.6u as=5.4312p ps=15.6u w=4.36u l=0.4u
X347 A GATE B A sg13_hv_pmos ad=5.4312p pd=15.6u as=5.4312p ps=15.6u w=4.36u l=0.4u
X348 B GATE A A sg13_hv_pmos ad=5.4312p pd=15.6u as=5.4312p ps=15.6u w=4.36u l=0.4u
X349 A GATE B A sg13_hv_pmos ad=5.4312p pd=15.6u as=5.4312p ps=15.6u w=4.36u l=0.4u
X350 A GATE B A sg13_hv_pmos ad=5.4312p pd=15.6u as=5.4312p ps=15.6u w=4.36u l=0.4u
X351 A GATE B A sg13_hv_pmos ad=5.4312p pd=15.6u as=5.4312p ps=15.6u w=4.36u l=0.4u
X352 B GATE A A sg13_hv_pmos ad=5.4312p pd=15.6u as=5.4312p ps=15.6u w=4.36u l=0.4u
X353 B GATE A A sg13_hv_pmos ad=5.4312p pd=15.6u as=5.4312p ps=15.6u w=4.36u l=0.4u
X354 B GATE A A sg13_hv_pmos ad=5.4312p pd=15.6u as=5.4312p ps=15.6u w=4.36u l=0.4u
X355 B GATE A A sg13_hv_pmos ad=5.4312p pd=15.6u as=5.4312p ps=15.6u w=4.36u l=0.4u
X356 A GATE B A sg13_hv_pmos ad=5.4312p pd=15.6u as=5.4312p ps=15.6u w=4.36u l=0.4u
X357 B GATE A A sg13_hv_pmos ad=5.4312p pd=15.6u as=5.4312p ps=15.6u w=4.36u l=0.4u
X358 A GATE B A sg13_hv_pmos ad=5.4312p pd=15.6u as=5.4312p ps=15.6u w=4.36u l=0.4u
X359 B GATE A A sg13_hv_pmos ad=5.4312p pd=15.6u as=5.4312p ps=15.6u w=4.36u l=0.4u
X360 A GATE B A sg13_hv_pmos ad=5.4312p pd=15.6u as=5.4312p ps=15.6u w=4.36u l=0.4u
X361 B GATE A A sg13_hv_pmos ad=5.4312p pd=15.6u as=5.4312p ps=15.6u w=4.36u l=0.4u
X362 A GATE B A sg13_hv_pmos ad=5.4312p pd=15.6u as=5.4312p ps=15.6u w=4.36u l=0.4u
X363 A GATE B A sg13_hv_pmos ad=5.4312p pd=15.6u as=5.4312p ps=15.6u w=4.36u l=0.4u
X364 B GATE A A sg13_hv_pmos ad=5.4312p pd=15.6u as=5.4312p ps=15.6u w=4.36u l=0.4u
X365 A GATE B A sg13_hv_pmos ad=5.4312p pd=15.6u as=5.4312p ps=15.6u w=4.36u l=0.4u
X366 B GATE A A sg13_hv_pmos ad=5.4312p pd=15.6u as=5.4312p ps=15.6u w=4.36u l=0.4u
X367 B GATE A A sg13_hv_pmos ad=5.4312p pd=15.6u as=5.4312p ps=15.6u w=4.36u l=0.4u
X368 A GATE B A sg13_hv_pmos ad=5.4312p pd=15.6u as=5.4312p ps=15.6u w=4.36u l=0.4u
X369 B GATE A A sg13_hv_pmos ad=5.4312p pd=15.6u as=5.4312p ps=15.6u w=4.36u l=0.4u
X370 B GATE A A sg13_hv_pmos ad=3.052p pd=10.12u as=5.4312p ps=15.6u w=4.36u l=0.4u
X371 A GATE B A sg13_hv_pmos ad=5.4312p pd=15.6u as=5.4312p ps=15.6u w=4.36u l=0.4u
X372 A GATE B A sg13_hv_pmos ad=5.4312p pd=15.6u as=5.4312p ps=15.6u w=4.36u l=0.4u
X373 B GATE A A sg13_hv_pmos ad=5.4312p pd=15.6u as=5.4312p ps=15.6u w=4.36u l=0.4u
X374 B GATE A A sg13_hv_pmos ad=5.4312p pd=15.6u as=5.4312p ps=15.6u w=4.36u l=0.4u
X375 A GATE B A sg13_hv_pmos ad=5.4312p pd=15.6u as=5.4312p ps=15.6u w=4.36u l=0.4u
X376 A GATE B A sg13_hv_pmos ad=5.4312p pd=15.6u as=3.052p ps=10.12u w=4.36u l=0.4u
X377 A GATE B A sg13_hv_pmos ad=5.4312p pd=15.6u as=5.4312p ps=15.6u w=4.36u l=0.4u
X378 A GATE B A sg13_hv_pmos ad=5.4312p pd=15.6u as=5.4312p ps=15.6u w=4.36u l=0.4u
X379 B GATE A A sg13_hv_pmos ad=5.4312p pd=15.6u as=5.4312p ps=15.6u w=4.36u l=0.4u
X380 A GATE B A sg13_hv_pmos ad=5.4312p pd=15.6u as=5.4312p ps=15.6u w=4.36u l=0.4u
X381 A GATE B A sg13_hv_pmos ad=5.4312p pd=15.6u as=5.4312p ps=15.6u w=4.36u l=0.4u
X382 B GATE A A sg13_hv_pmos ad=5.4312p pd=15.6u as=5.4312p ps=15.6u w=4.36u l=0.4u
X383 B GATE A A sg13_hv_pmos ad=5.4312p pd=15.6u as=5.4312p ps=15.6u w=4.36u l=0.4u
X384 B GATE A A sg13_hv_pmos ad=5.4312p pd=15.6u as=5.4312p ps=15.6u w=4.36u l=0.4u
X385 A GATE B A sg13_hv_pmos ad=5.4312p pd=15.6u as=5.4312p ps=15.6u w=4.36u l=0.4u
X386 B GATE A A sg13_hv_pmos ad=5.4312p pd=15.6u as=5.4312p ps=15.6u w=4.36u l=0.4u
X387 A GATE B A sg13_hv_pmos ad=5.4312p pd=15.6u as=5.4312p ps=15.6u w=4.36u l=0.4u
X388 B GATE A A sg13_hv_pmos ad=5.4312p pd=15.6u as=5.4312p ps=15.6u w=4.36u l=0.4u
X389 A GATE B A sg13_hv_pmos ad=5.4312p pd=15.6u as=5.4312p ps=15.6u w=4.36u l=0.4u
X390 B GATE A A sg13_hv_pmos ad=5.4312p pd=15.6u as=5.4312p ps=15.6u w=4.36u l=0.4u
X391 A GATE B A sg13_hv_pmos ad=5.4312p pd=15.6u as=5.4312p ps=15.6u w=4.36u l=0.4u
X392 A GATE B A sg13_hv_pmos ad=5.4312p pd=15.6u as=5.4312p ps=15.6u w=4.36u l=0.4u
X393 B GATE A A sg13_hv_pmos ad=5.4312p pd=15.6u as=5.4312p ps=15.6u w=4.36u l=0.4u
X394 B GATE A A sg13_hv_pmos ad=5.4312p pd=15.6u as=5.4312p ps=15.6u w=4.36u l=0.4u
X395 A GATE B A sg13_hv_pmos ad=5.4312p pd=15.6u as=5.4312p ps=15.6u w=4.36u l=0.4u
X396 B GATE A A sg13_hv_pmos ad=5.4312p pd=15.6u as=5.4312p ps=15.6u w=4.36u l=0.4u
X397 A GATE B A sg13_hv_pmos ad=5.4312p pd=15.6u as=5.4312p ps=15.6u w=4.36u l=0.4u
X398 A GATE B A sg13_hv_pmos ad=5.4312p pd=15.6u as=5.4312p ps=15.6u w=4.36u l=0.4u
X399 B GATE A A sg13_hv_pmos ad=5.4312p pd=15.6u as=5.4312p ps=15.6u w=4.36u l=0.4u
X400 B GATE A A sg13_hv_pmos ad=5.4312p pd=15.6u as=5.4312p ps=15.6u w=4.36u l=0.4u
X401 B GATE A A sg13_hv_pmos ad=5.4312p pd=15.6u as=3.052p ps=10.12u w=4.36u l=0.4u
X402 A GATE B A sg13_hv_pmos ad=5.4312p pd=15.6u as=3.052p ps=10.12u w=4.36u l=0.4u
X403 A GATE B A sg13_hv_pmos ad=5.4312p pd=15.6u as=5.4312p ps=15.6u w=4.36u l=0.4u
X404 A GATE B A sg13_hv_pmos ad=5.4312p pd=15.6u as=3.052p ps=10.12u w=4.36u l=0.4u
X405 A GATE B A sg13_hv_pmos ad=3.052p pd=10.12u as=5.4312p ps=15.6u w=4.36u l=0.4u
X406 A GATE B A sg13_hv_pmos ad=5.4312p pd=15.6u as=5.4312p ps=15.6u w=4.36u l=0.4u
X407 B GATE A A sg13_hv_pmos ad=5.4312p pd=15.6u as=5.4312p ps=15.6u w=4.36u l=0.4u
X408 A GATE B A sg13_hv_pmos ad=5.4312p pd=15.6u as=5.4312p ps=15.6u w=4.36u l=0.4u
X409 B GATE A A sg13_hv_pmos ad=5.4312p pd=15.6u as=5.4312p ps=15.6u w=4.36u l=0.4u
X410 A GATE B A sg13_hv_pmos ad=5.4312p pd=15.6u as=5.4312p ps=15.6u w=4.36u l=0.4u
X411 B GATE A A sg13_hv_pmos ad=5.4312p pd=15.6u as=5.4312p ps=15.6u w=4.36u l=0.4u
X412 B GATE A A sg13_hv_pmos ad=5.4312p pd=15.6u as=5.4312p ps=15.6u w=4.36u l=0.4u
X413 B GATE A A sg13_hv_pmos ad=5.4312p pd=15.6u as=5.4312p ps=15.6u w=4.36u l=0.4u
X414 B GATE A A sg13_hv_pmos ad=5.4312p pd=15.6u as=5.4312p ps=15.6u w=4.36u l=0.4u
X415 A GATE B A sg13_hv_pmos ad=5.4312p pd=15.6u as=5.4312p ps=15.6u w=4.36u l=0.4u
X416 A GATE B A sg13_hv_pmos ad=5.4312p pd=15.6u as=5.4312p ps=15.6u w=4.36u l=0.4u
X417 B GATE A A sg13_hv_pmos ad=5.4312p pd=15.6u as=5.4312p ps=15.6u w=4.36u l=0.4u
X418 A GATE B A sg13_hv_pmos ad=5.4312p pd=15.6u as=5.4312p ps=15.6u w=4.36u l=0.4u
X419 A GATE B A sg13_hv_pmos ad=5.4312p pd=15.6u as=5.4312p ps=15.6u w=4.36u l=0.4u
X420 B GATE A A sg13_hv_pmos ad=5.4312p pd=15.6u as=5.4312p ps=15.6u w=4.36u l=0.4u
X421 A GATE B A sg13_hv_pmos ad=5.4312p pd=15.6u as=5.4312p ps=15.6u w=4.36u l=0.4u
X422 B GATE A A sg13_hv_pmos ad=5.4312p pd=15.6u as=5.4312p ps=15.6u w=4.36u l=0.4u
X423 A GATE B A sg13_hv_pmos ad=5.4312p pd=15.6u as=5.4312p ps=15.6u w=4.36u l=0.4u
X424 B GATE A A sg13_hv_pmos ad=5.4312p pd=15.6u as=5.4312p ps=15.6u w=4.36u l=0.4u
X425 B GATE A A sg13_hv_pmos ad=5.4312p pd=15.6u as=5.4312p ps=15.6u w=4.36u l=0.4u
X426 B GATE A A sg13_hv_pmos ad=5.4312p pd=15.6u as=5.4312p ps=15.6u w=4.36u l=0.4u
X427 A GATE B A sg13_hv_pmos ad=5.4312p pd=15.6u as=5.4312p ps=15.6u w=4.36u l=0.4u
X428 A GATE B A sg13_hv_pmos ad=5.4312p pd=15.6u as=3.052p ps=10.12u w=4.36u l=0.4u
X429 A GATE B A sg13_hv_pmos ad=5.4312p pd=15.6u as=5.4312p ps=15.6u w=4.36u l=0.4u
X430 B GATE A A sg13_hv_pmos ad=5.4312p pd=15.6u as=5.4312p ps=15.6u w=4.36u l=0.4u
X431 A GATE B A sg13_hv_pmos ad=5.4312p pd=15.6u as=5.4312p ps=15.6u w=4.36u l=0.4u
X432 A GATE B A sg13_hv_pmos ad=5.4312p pd=15.6u as=5.4312p ps=15.6u w=4.36u l=0.4u
X433 B GATE A A sg13_hv_pmos ad=5.4312p pd=15.6u as=5.4312p ps=15.6u w=4.36u l=0.4u
X434 B GATE A A sg13_hv_pmos ad=3.052p pd=10.12u as=5.4312p ps=15.6u w=4.36u l=0.4u
X435 B GATE A A sg13_hv_pmos ad=5.4312p pd=15.6u as=5.4312p ps=15.6u w=4.36u l=0.4u
X436 A GATE B A sg13_hv_pmos ad=5.4312p pd=15.6u as=5.4312p ps=15.6u w=4.36u l=0.4u
X437 B GATE A A sg13_hv_pmos ad=5.4312p pd=15.6u as=5.4312p ps=15.6u w=4.36u l=0.4u
X438 A GATE B A sg13_hv_pmos ad=5.4312p pd=15.6u as=5.4312p ps=15.6u w=4.36u l=0.4u
X439 B GATE A A sg13_hv_pmos ad=5.4312p pd=15.6u as=5.4312p ps=15.6u w=4.36u l=0.4u
X440 B GATE A A sg13_hv_pmos ad=5.4312p pd=15.6u as=5.4312p ps=15.6u w=4.36u l=0.4u
X441 A GATE B A sg13_hv_pmos ad=5.4312p pd=15.6u as=5.4312p ps=15.6u w=4.36u l=0.4u
X442 A GATE B A sg13_hv_pmos ad=5.4312p pd=15.6u as=5.4312p ps=15.6u w=4.36u l=0.4u
X443 A GATE B A sg13_hv_pmos ad=5.4312p pd=15.6u as=5.4312p ps=15.6u w=4.36u l=0.4u
X444 A GATE B A sg13_hv_pmos ad=5.4312p pd=15.6u as=5.4312p ps=15.6u w=4.36u l=0.4u
X445 A GATE B A sg13_hv_pmos ad=5.4312p pd=15.6u as=5.4312p ps=15.6u w=4.36u l=0.4u
X446 B GATE A A sg13_hv_pmos ad=5.4312p pd=15.6u as=5.4312p ps=15.6u w=4.36u l=0.4u
X447 B GATE A A sg13_hv_pmos ad=5.4312p pd=15.6u as=5.4312p ps=15.6u w=4.36u l=0.4u
X448 B GATE A A sg13_hv_pmos ad=5.4312p pd=15.6u as=5.4312p ps=15.6u w=4.36u l=0.4u
X449 A GATE B A sg13_hv_pmos ad=5.4312p pd=15.6u as=5.4312p ps=15.6u w=4.36u l=0.4u
X450 B GATE A A sg13_hv_pmos ad=5.4312p pd=15.6u as=5.4312p ps=15.6u w=4.36u l=0.4u
X451 A GATE B A sg13_hv_pmos ad=5.4312p pd=15.6u as=5.4312p ps=15.6u w=4.36u l=0.4u
X452 B GATE A A sg13_hv_pmos ad=5.4312p pd=15.6u as=5.4312p ps=15.6u w=4.36u l=0.4u
X453 A GATE B A sg13_hv_pmos ad=5.4312p pd=15.6u as=5.4312p ps=15.6u w=4.36u l=0.4u
X454 A GATE B A sg13_hv_pmos ad=5.4312p pd=15.6u as=5.4312p ps=15.6u w=4.36u l=0.4u
X455 A GATE B A sg13_hv_pmos ad=5.4312p pd=15.6u as=5.4312p ps=15.6u w=4.36u l=0.4u
X456 B GATE A A sg13_hv_pmos ad=5.4312p pd=15.6u as=5.4312p ps=15.6u w=4.36u l=0.4u
X457 B GATE A A sg13_hv_pmos ad=5.4312p pd=15.6u as=5.4312p ps=15.6u w=4.36u l=0.4u
X458 A GATE B A sg13_hv_pmos ad=5.4312p pd=15.6u as=5.4312p ps=15.6u w=4.36u l=0.4u
X459 B GATE A A sg13_hv_pmos ad=5.4312p pd=15.6u as=5.4312p ps=15.6u w=4.36u l=0.4u
X460 B GATE A A sg13_hv_pmos ad=5.4312p pd=15.6u as=5.4312p ps=15.6u w=4.36u l=0.4u
X461 B GATE A A sg13_hv_pmos ad=5.4312p pd=15.6u as=5.4312p ps=15.6u w=4.36u l=0.4u
X462 A GATE B A sg13_hv_pmos ad=5.4312p pd=15.6u as=5.4312p ps=15.6u w=4.36u l=0.4u
X463 B GATE A A sg13_hv_pmos ad=5.4312p pd=15.6u as=5.4312p ps=15.6u w=4.36u l=0.4u
X464 A GATE B A sg13_hv_pmos ad=3.052p pd=10.12u as=5.4312p ps=15.6u w=4.36u l=0.4u
X465 A GATE B A sg13_hv_pmos ad=5.4312p pd=15.6u as=5.4312p ps=15.6u w=4.36u l=0.4u
X466 A GATE B A sg13_hv_pmos ad=5.4312p pd=15.6u as=5.4312p ps=15.6u w=4.36u l=0.4u
X467 A GATE B A sg13_hv_pmos ad=5.4312p pd=15.6u as=5.4312p ps=15.6u w=4.36u l=0.4u
X468 A GATE B A sg13_hv_pmos ad=5.4312p pd=15.6u as=5.4312p ps=15.6u w=4.36u l=0.4u
X469 B GATE A A sg13_hv_pmos ad=5.4312p pd=15.6u as=5.4312p ps=15.6u w=4.36u l=0.4u
X470 B GATE A A sg13_hv_pmos ad=5.4312p pd=15.6u as=5.4312p ps=15.6u w=4.36u l=0.4u
X471 B GATE A A sg13_hv_pmos ad=5.4312p pd=15.6u as=5.4312p ps=15.6u w=4.36u l=0.4u
X472 B GATE A A sg13_hv_pmos ad=5.4312p pd=15.6u as=5.4312p ps=15.6u w=4.36u l=0.4u
X473 B GATE A A sg13_hv_pmos ad=5.4312p pd=15.6u as=5.4312p ps=15.6u w=4.36u l=0.4u
X474 A GATE B A sg13_hv_pmos ad=5.4312p pd=15.6u as=5.4312p ps=15.6u w=4.36u l=0.4u
X475 A GATE B A sg13_hv_pmos ad=5.4312p pd=15.6u as=5.4312p ps=15.6u w=4.36u l=0.4u
X476 B GATE A A sg13_hv_pmos ad=5.4312p pd=15.6u as=5.4312p ps=15.6u w=4.36u l=0.4u
X477 A GATE B A sg13_hv_pmos ad=5.4312p pd=15.6u as=5.4312p ps=15.6u w=4.36u l=0.4u
X478 B GATE A A sg13_hv_pmos ad=5.4312p pd=15.6u as=5.4312p ps=15.6u w=4.36u l=0.4u
X479 A GATE B A sg13_hv_pmos ad=5.4312p pd=15.6u as=5.4312p ps=15.6u w=4.36u l=0.4u
X480 A GATE B A sg13_hv_pmos ad=5.4312p pd=15.6u as=5.4312p ps=15.6u w=4.36u l=0.4u
X481 A GATE B A sg13_hv_pmos ad=5.4312p pd=15.6u as=5.4312p ps=15.6u w=4.36u l=0.4u
X482 B GATE A A sg13_hv_pmos ad=5.4312p pd=15.6u as=5.4312p ps=15.6u w=4.36u l=0.4u
X483 A GATE B A sg13_hv_pmos ad=5.4312p pd=15.6u as=5.4312p ps=15.6u w=4.36u l=0.4u
X484 B GATE A A sg13_hv_pmos ad=5.4312p pd=15.6u as=5.4312p ps=15.6u w=4.36u l=0.4u
X485 B GATE A A sg13_hv_pmos ad=5.4312p pd=15.6u as=5.4312p ps=15.6u w=4.36u l=0.4u
X486 A GATE B A sg13_hv_pmos ad=5.4312p pd=15.6u as=5.4312p ps=15.6u w=4.36u l=0.4u
X487 B GATE A A sg13_hv_pmos ad=5.4312p pd=15.6u as=5.4312p ps=15.6u w=4.36u l=0.4u
X488 A GATE B A sg13_hv_pmos ad=5.4312p pd=15.6u as=5.4312p ps=15.6u w=4.36u l=0.4u
X489 A GATE B A sg13_hv_pmos ad=5.4312p pd=15.6u as=5.4312p ps=15.6u w=4.36u l=0.4u
X490 A GATE B A sg13_hv_pmos ad=5.4312p pd=15.6u as=5.4312p ps=15.6u w=4.36u l=0.4u
X491 A GATE B A sg13_hv_pmos ad=5.4312p pd=15.6u as=5.4312p ps=15.6u w=4.36u l=0.4u
X492 B GATE A A sg13_hv_pmos ad=5.4312p pd=15.6u as=5.4312p ps=15.6u w=4.36u l=0.4u
X493 B GATE A A sg13_hv_pmos ad=3.052p pd=10.12u as=5.4312p ps=15.6u w=4.36u l=0.4u
X494 A GATE B A sg13_hv_pmos ad=5.4312p pd=15.6u as=5.4312p ps=15.6u w=4.36u l=0.4u
X495 B GATE A A sg13_hv_pmos ad=5.4312p pd=15.6u as=5.4312p ps=15.6u w=4.36u l=0.4u
X496 A GATE B A sg13_hv_pmos ad=5.4312p pd=15.6u as=5.4312p ps=15.6u w=4.36u l=0.4u
X497 B GATE A A sg13_hv_pmos ad=5.4312p pd=15.6u as=5.4312p ps=15.6u w=4.36u l=0.4u
X498 B GATE A A sg13_hv_pmos ad=5.4312p pd=15.6u as=5.4312p ps=15.6u w=4.36u l=0.4u
X499 A GATE B A sg13_hv_pmos ad=5.4312p pd=15.6u as=5.4312p ps=15.6u w=4.36u l=0.4u
X500 B GATE A A sg13_hv_pmos ad=5.4312p pd=15.6u as=5.4312p ps=15.6u w=4.36u l=0.4u
X501 A GATE B A sg13_hv_pmos ad=5.4312p pd=15.6u as=5.4312p ps=15.6u w=4.36u l=0.4u
X502 A GATE B A sg13_hv_pmos ad=5.4312p pd=15.6u as=5.4312p ps=15.6u w=4.36u l=0.4u
X503 B GATE A A sg13_hv_pmos ad=5.4312p pd=15.6u as=5.4312p ps=15.6u w=4.36u l=0.4u
X504 A GATE B A sg13_hv_pmos ad=5.4312p pd=15.6u as=5.4312p ps=15.6u w=4.36u l=0.4u
X505 A GATE B A sg13_hv_pmos ad=5.4312p pd=15.6u as=5.4312p ps=15.6u w=4.36u l=0.4u
X506 A GATE B A sg13_hv_pmos ad=5.4312p pd=15.6u as=5.4312p ps=15.6u w=4.36u l=0.4u
X507 B GATE A A sg13_hv_pmos ad=5.4312p pd=15.6u as=5.4312p ps=15.6u w=4.36u l=0.4u
X508 B GATE A A sg13_hv_pmos ad=5.4312p pd=15.6u as=5.4312p ps=15.6u w=4.36u l=0.4u
X509 B GATE A A sg13_hv_pmos ad=5.4312p pd=15.6u as=5.4312p ps=15.6u w=4.36u l=0.4u
X510 B GATE A A sg13_hv_pmos ad=5.4312p pd=15.6u as=5.4312p ps=15.6u w=4.36u l=0.4u
X511 A GATE B A sg13_hv_pmos ad=5.4312p pd=15.6u as=5.4312p ps=15.6u w=4.36u l=0.4u
X512 B GATE A A sg13_hv_pmos ad=5.4312p pd=15.6u as=5.4312p ps=15.6u w=4.36u l=0.4u
X513 A GATE B A sg13_hv_pmos ad=5.4312p pd=15.6u as=5.4312p ps=15.6u w=4.36u l=0.4u
X514 B GATE A A sg13_hv_pmos ad=5.4312p pd=15.6u as=5.4312p ps=15.6u w=4.36u l=0.4u
X515 A GATE B A sg13_hv_pmos ad=5.4312p pd=15.6u as=5.4312p ps=15.6u w=4.36u l=0.4u
X516 B GATE A A sg13_hv_pmos ad=5.4312p pd=15.6u as=5.4312p ps=15.6u w=4.36u l=0.4u
X517 A GATE B A sg13_hv_pmos ad=5.4312p pd=15.6u as=5.4312p ps=15.6u w=4.36u l=0.4u
X518 B GATE A A sg13_hv_pmos ad=5.4312p pd=15.6u as=5.4312p ps=15.6u w=4.36u l=0.4u
X519 A GATE B A sg13_hv_pmos ad=5.4312p pd=15.6u as=5.4312p ps=15.6u w=4.36u l=0.4u
X520 B GATE A A sg13_hv_pmos ad=5.4312p pd=15.6u as=5.4312p ps=15.6u w=4.36u l=0.4u
X521 B GATE A A sg13_hv_pmos ad=5.4312p pd=15.6u as=5.4312p ps=15.6u w=4.36u l=0.4u
X522 B GATE A A sg13_hv_pmos ad=5.4312p pd=15.6u as=5.4312p ps=15.6u w=4.36u l=0.4u
X523 A GATE B A sg13_hv_pmos ad=5.4312p pd=15.6u as=5.4312p ps=15.6u w=4.36u l=0.4u
X524 A GATE B A sg13_hv_pmos ad=3.052p pd=10.12u as=5.4312p ps=15.6u w=4.36u l=0.4u
X525 B GATE A A sg13_hv_pmos ad=5.4312p pd=15.6u as=5.4312p ps=15.6u w=4.36u l=0.4u
X526 A GATE B A sg13_hv_pmos ad=5.4312p pd=15.6u as=5.4312p ps=15.6u w=4.36u l=0.4u
X527 B GATE A A sg13_hv_pmos ad=5.4312p pd=15.6u as=5.4312p ps=15.6u w=4.36u l=0.4u
X528 A GATE B A sg13_hv_pmos ad=5.4312p pd=15.6u as=5.4312p ps=15.6u w=4.36u l=0.4u
X529 A GATE B A sg13_hv_pmos ad=5.4312p pd=15.6u as=5.4312p ps=15.6u w=4.36u l=0.4u
X530 A GATE B A sg13_hv_pmos ad=5.4312p pd=15.6u as=5.4312p ps=15.6u w=4.36u l=0.4u
X531 A GATE B A sg13_hv_pmos ad=5.4312p pd=15.6u as=5.4312p ps=15.6u w=4.36u l=0.4u
X532 B GATE A A sg13_hv_pmos ad=5.4312p pd=15.6u as=5.4312p ps=15.6u w=4.36u l=0.4u
X533 A GATE B A sg13_hv_pmos ad=5.4312p pd=15.6u as=5.4312p ps=15.6u w=4.36u l=0.4u
X534 B GATE A A sg13_hv_pmos ad=5.4312p pd=15.6u as=5.4312p ps=15.6u w=4.36u l=0.4u
X535 A GATE B A sg13_hv_pmos ad=5.4312p pd=15.6u as=5.4312p ps=15.6u w=4.36u l=0.4u
X536 A GATE B A sg13_hv_pmos ad=5.4312p pd=15.6u as=5.4312p ps=15.6u w=4.36u l=0.4u
X537 B GATE A A sg13_hv_pmos ad=5.4312p pd=15.6u as=5.4312p ps=15.6u w=4.36u l=0.4u
X538 A GATE B A sg13_hv_pmos ad=5.4312p pd=15.6u as=5.4312p ps=15.6u w=4.36u l=0.4u
X539 B GATE A A sg13_hv_pmos ad=5.4312p pd=15.6u as=5.4312p ps=15.6u w=4.36u l=0.4u
X540 A GATE B A sg13_hv_pmos ad=5.4312p pd=15.6u as=5.4312p ps=15.6u w=4.36u l=0.4u
X541 B GATE A A sg13_hv_pmos ad=5.4312p pd=15.6u as=5.4312p ps=15.6u w=4.36u l=0.4u
X542 A GATE B A sg13_hv_pmos ad=5.4312p pd=15.6u as=5.4312p ps=15.6u w=4.36u l=0.4u
X543 A GATE B A sg13_hv_pmos ad=5.4312p pd=15.6u as=5.4312p ps=15.6u w=4.36u l=0.4u
X544 B GATE A A sg13_hv_pmos ad=5.4312p pd=15.6u as=5.4312p ps=15.6u w=4.36u l=0.4u
X545 A GATE B A sg13_hv_pmos ad=5.4312p pd=15.6u as=5.4312p ps=15.6u w=4.36u l=0.4u
X546 B GATE A A sg13_hv_pmos ad=5.4312p pd=15.6u as=5.4312p ps=15.6u w=4.36u l=0.4u
X547 B GATE A A sg13_hv_pmos ad=5.4312p pd=15.6u as=5.4312p ps=15.6u w=4.36u l=0.4u
X548 A GATE B A sg13_hv_pmos ad=5.4312p pd=15.6u as=5.4312p ps=15.6u w=4.36u l=0.4u
X549 B GATE A A sg13_hv_pmos ad=5.4312p pd=15.6u as=5.4312p ps=15.6u w=4.36u l=0.4u
X550 B GATE A A sg13_hv_pmos ad=5.4312p pd=15.6u as=5.4312p ps=15.6u w=4.36u l=0.4u
X551 A GATE B A sg13_hv_pmos ad=5.4312p pd=15.6u as=5.4312p ps=15.6u w=4.36u l=0.4u
X552 A GATE B A sg13_hv_pmos ad=5.4312p pd=15.6u as=5.4312p ps=15.6u w=4.36u l=0.4u
X553 A GATE B A sg13_hv_pmos ad=5.4312p pd=15.6u as=5.4312p ps=15.6u w=4.36u l=0.4u
X554 A GATE B A sg13_hv_pmos ad=5.4312p pd=15.6u as=5.4312p ps=15.6u w=4.36u l=0.4u
X555 A GATE B A sg13_hv_pmos ad=5.4312p pd=15.6u as=5.4312p ps=15.6u w=4.36u l=0.4u
X556 B GATE A A sg13_hv_pmos ad=5.4312p pd=15.6u as=5.4312p ps=15.6u w=4.36u l=0.4u
X557 B GATE A A sg13_hv_pmos ad=3.052p pd=10.12u as=5.4312p ps=15.6u w=4.36u l=0.4u
X558 A GATE B A sg13_hv_pmos ad=5.4312p pd=15.6u as=5.4312p ps=15.6u w=4.36u l=0.4u
X559 B GATE A A sg13_hv_pmos ad=5.4312p pd=15.6u as=5.4312p ps=15.6u w=4.36u l=0.4u
X560 A GATE B A sg13_hv_pmos ad=5.4312p pd=15.6u as=5.4312p ps=15.6u w=4.36u l=0.4u
X561 B GATE A A sg13_hv_pmos ad=5.4312p pd=15.6u as=5.4312p ps=15.6u w=4.36u l=0.4u
X562 B GATE A A sg13_hv_pmos ad=5.4312p pd=15.6u as=5.4312p ps=15.6u w=4.36u l=0.4u
X563 A GATE B A sg13_hv_pmos ad=5.4312p pd=15.6u as=5.4312p ps=15.6u w=4.36u l=0.4u
X564 B GATE A A sg13_hv_pmos ad=5.4312p pd=15.6u as=5.4312p ps=15.6u w=4.36u l=0.4u
X565 A GATE B A sg13_hv_pmos ad=5.4312p pd=15.6u as=5.4312p ps=15.6u w=4.36u l=0.4u
X566 B GATE A A sg13_hv_pmos ad=5.4312p pd=15.6u as=5.4312p ps=15.6u w=4.36u l=0.4u
X567 B GATE A A sg13_hv_pmos ad=5.4312p pd=15.6u as=5.4312p ps=15.6u w=4.36u l=0.4u
X568 A GATE B A sg13_hv_pmos ad=5.4312p pd=15.6u as=5.4312p ps=15.6u w=4.36u l=0.4u
X569 B GATE A A sg13_hv_pmos ad=5.4312p pd=15.6u as=5.4312p ps=15.6u w=4.36u l=0.4u
X570 A GATE B A sg13_hv_pmos ad=5.4312p pd=15.6u as=5.4312p ps=15.6u w=4.36u l=0.4u
X571 B GATE A A sg13_hv_pmos ad=5.4312p pd=15.6u as=5.4312p ps=15.6u w=4.36u l=0.4u
X572 A GATE B A sg13_hv_pmos ad=5.4312p pd=15.6u as=5.4312p ps=15.6u w=4.36u l=0.4u
X573 B GATE A A sg13_hv_pmos ad=5.4312p pd=15.6u as=5.4312p ps=15.6u w=4.36u l=0.4u
X574 B GATE A A sg13_hv_pmos ad=5.4312p pd=15.6u as=5.4312p ps=15.6u w=4.36u l=0.4u
X575 B GATE A A sg13_hv_pmos ad=5.4312p pd=15.6u as=5.4312p ps=15.6u w=4.36u l=0.4u
X576 A GATE B A sg13_hv_pmos ad=5.4312p pd=15.6u as=5.4312p ps=15.6u w=4.36u l=0.4u
X577 B GATE A A sg13_hv_pmos ad=5.4312p pd=15.6u as=5.4312p ps=15.6u w=4.36u l=0.4u
X578 A GATE B A sg13_hv_pmos ad=5.4312p pd=15.6u as=5.4312p ps=15.6u w=4.36u l=0.4u
X579 B GATE A A sg13_hv_pmos ad=5.4312p pd=15.6u as=5.4312p ps=15.6u w=4.36u l=0.4u
X580 A GATE B A sg13_hv_pmos ad=5.4312p pd=15.6u as=5.4312p ps=15.6u w=4.36u l=0.4u
X581 B GATE A A sg13_hv_pmos ad=5.4312p pd=15.6u as=5.4312p ps=15.6u w=4.36u l=0.4u
X582 A GATE B A sg13_hv_pmos ad=5.4312p pd=15.6u as=5.4312p ps=15.6u w=4.36u l=0.4u
X583 A GATE B A sg13_hv_pmos ad=5.4312p pd=15.6u as=5.4312p ps=15.6u w=4.36u l=0.4u
X584 B GATE A A sg13_hv_pmos ad=5.4312p pd=15.6u as=5.4312p ps=15.6u w=4.36u l=0.4u
X585 B GATE A A sg13_hv_pmos ad=5.4312p pd=15.6u as=3.052p ps=10.12u w=4.36u l=0.4u
X586 A GATE B A sg13_hv_pmos ad=5.4312p pd=15.6u as=5.4312p ps=15.6u w=4.36u l=0.4u
X587 B GATE A A sg13_hv_pmos ad=5.4312p pd=15.6u as=5.4312p ps=15.6u w=4.36u l=0.4u
X588 B GATE A A sg13_hv_pmos ad=5.4312p pd=15.6u as=5.4312p ps=15.6u w=4.36u l=0.4u
X589 A GATE B A sg13_hv_pmos ad=3.052p pd=10.12u as=5.4312p ps=15.6u w=4.36u l=0.4u
X590 B GATE A A sg13_hv_pmos ad=5.4312p pd=15.6u as=5.4312p ps=15.6u w=4.36u l=0.4u
X591 A GATE B A sg13_hv_pmos ad=5.4312p pd=15.6u as=5.4312p ps=15.6u w=4.36u l=0.4u
X592 A GATE B A sg13_hv_pmos ad=5.4312p pd=15.6u as=5.4312p ps=15.6u w=4.36u l=0.4u
X593 B GATE A A sg13_hv_pmos ad=5.4312p pd=15.6u as=5.4312p ps=15.6u w=4.36u l=0.4u
X594 A GATE B A sg13_hv_pmos ad=5.4312p pd=15.6u as=5.4312p ps=15.6u w=4.36u l=0.4u
X595 B GATE A A sg13_hv_pmos ad=5.4312p pd=15.6u as=5.4312p ps=15.6u w=4.36u l=0.4u
X596 A GATE B A sg13_hv_pmos ad=5.4312p pd=15.6u as=5.4312p ps=15.6u w=4.36u l=0.4u
X597 A GATE B A sg13_hv_pmos ad=5.4312p pd=15.6u as=5.4312p ps=15.6u w=4.36u l=0.4u
X598 B GATE A A sg13_hv_pmos ad=5.4312p pd=15.6u as=5.4312p ps=15.6u w=4.36u l=0.4u
X599 A GATE B A sg13_hv_pmos ad=5.4312p pd=15.6u as=5.4312p ps=15.6u w=4.36u l=0.4u
X600 B GATE A A sg13_hv_pmos ad=5.4312p pd=15.6u as=5.4312p ps=15.6u w=4.36u l=0.4u
X601 A GATE B A sg13_hv_pmos ad=5.4312p pd=15.6u as=5.4312p ps=15.6u w=4.36u l=0.4u
X602 B GATE A A sg13_hv_pmos ad=5.4312p pd=15.6u as=5.4312p ps=15.6u w=4.36u l=0.4u
X603 A GATE B A sg13_hv_pmos ad=5.4312p pd=15.6u as=5.4312p ps=15.6u w=4.36u l=0.4u
X604 A GATE B A sg13_hv_pmos ad=5.4312p pd=15.6u as=5.4312p ps=15.6u w=4.36u l=0.4u
X605 A GATE B A sg13_hv_pmos ad=5.4312p pd=15.6u as=5.4312p ps=15.6u w=4.36u l=0.4u
X606 B GATE A A sg13_hv_pmos ad=5.4312p pd=15.6u as=3.052p ps=10.12u w=4.36u l=0.4u
X607 B GATE A A sg13_hv_pmos ad=5.4312p pd=15.6u as=5.4312p ps=15.6u w=4.36u l=0.4u
X608 A GATE B A sg13_hv_pmos ad=5.4312p pd=15.6u as=5.4312p ps=15.6u w=4.36u l=0.4u
X609 B GATE A A sg13_hv_pmos ad=5.4312p pd=15.6u as=5.4312p ps=15.6u w=4.36u l=0.4u
X610 B GATE A A sg13_hv_pmos ad=5.4312p pd=15.6u as=3.052p ps=10.12u w=4.36u l=0.4u
X611 B GATE A A sg13_hv_pmos ad=5.4312p pd=15.6u as=3.052p ps=10.12u w=4.36u l=0.4u
X612 A GATE B A sg13_hv_pmos ad=5.4312p pd=15.6u as=5.4312p ps=15.6u w=4.36u l=0.4u
X613 B GATE A A sg13_hv_pmos ad=5.4312p pd=15.6u as=5.4312p ps=15.6u w=4.36u l=0.4u
X614 A GATE B A sg13_hv_pmos ad=5.4312p pd=15.6u as=5.4312p ps=15.6u w=4.36u l=0.4u
X615 B GATE A A sg13_hv_pmos ad=5.4312p pd=15.6u as=5.4312p ps=15.6u w=4.36u l=0.4u
X616 B GATE A A sg13_hv_pmos ad=5.4312p pd=15.6u as=5.4312p ps=15.6u w=4.36u l=0.4u
X617 A GATE B A sg13_hv_pmos ad=5.4312p pd=15.6u as=5.4312p ps=15.6u w=4.36u l=0.4u
X618 B GATE A A sg13_hv_pmos ad=5.4312p pd=15.6u as=5.4312p ps=15.6u w=4.36u l=0.4u
X619 A GATE B A sg13_hv_pmos ad=5.4312p pd=15.6u as=5.4312p ps=15.6u w=4.36u l=0.4u
X620 A GATE B A sg13_hv_pmos ad=5.4312p pd=15.6u as=5.4312p ps=15.6u w=4.36u l=0.4u
X621 A GATE B A sg13_hv_pmos ad=5.4312p pd=15.6u as=5.4312p ps=15.6u w=4.36u l=0.4u
X622 B GATE A A sg13_hv_pmos ad=5.4312p pd=15.6u as=5.4312p ps=15.6u w=4.36u l=0.4u
X623 B GATE A A sg13_hv_pmos ad=5.4312p pd=15.6u as=5.4312p ps=15.6u w=4.36u l=0.4u
X624 A GATE B A sg13_hv_pmos ad=5.4312p pd=15.6u as=5.4312p ps=15.6u w=4.36u l=0.4u
X625 B GATE A A sg13_hv_pmos ad=5.4312p pd=15.6u as=5.4312p ps=15.6u w=4.36u l=0.4u
X626 B GATE A A sg13_hv_pmos ad=5.4312p pd=15.6u as=5.4312p ps=15.6u w=4.36u l=0.4u
X627 A GATE B A sg13_hv_pmos ad=5.4312p pd=15.6u as=5.4312p ps=15.6u w=4.36u l=0.4u
X628 B GATE A A sg13_hv_pmos ad=5.4312p pd=15.6u as=5.4312p ps=15.6u w=4.36u l=0.4u
X629 A GATE B A sg13_hv_pmos ad=5.4312p pd=15.6u as=5.4312p ps=15.6u w=4.36u l=0.4u
X630 A GATE B A sg13_hv_pmos ad=5.4312p pd=15.6u as=5.4312p ps=15.6u w=4.36u l=0.4u
X631 B GATE A A sg13_hv_pmos ad=5.4312p pd=15.6u as=5.4312p ps=15.6u w=4.36u l=0.4u
X632 B GATE A A sg13_hv_pmos ad=5.4312p pd=15.6u as=5.4312p ps=15.6u w=4.36u l=0.4u
X633 B GATE A A sg13_hv_pmos ad=5.4312p pd=15.6u as=5.4312p ps=15.6u w=4.36u l=0.4u
X634 B GATE A A sg13_hv_pmos ad=5.4312p pd=15.6u as=3.052p ps=10.12u w=4.36u l=0.4u
X635 A GATE B A sg13_hv_pmos ad=5.4312p pd=15.6u as=5.4312p ps=15.6u w=4.36u l=0.4u
X636 B GATE A A sg13_hv_pmos ad=5.4312p pd=15.6u as=5.4312p ps=15.6u w=4.36u l=0.4u
X637 A GATE B A sg13_hv_pmos ad=5.4312p pd=15.6u as=3.052p ps=10.12u w=4.36u l=0.4u
X638 B GATE A A sg13_hv_pmos ad=5.4312p pd=15.6u as=5.4312p ps=15.6u w=4.36u l=0.4u
X639 B GATE A A sg13_hv_pmos ad=5.4312p pd=15.6u as=5.4312p ps=15.6u w=4.36u l=0.4u
X640 A GATE B A sg13_hv_pmos ad=5.4312p pd=15.6u as=5.4312p ps=15.6u w=4.36u l=0.4u
X641 B GATE A A sg13_hv_pmos ad=5.4312p pd=15.6u as=5.4312p ps=15.6u w=4.36u l=0.4u
X642 A GATE B A sg13_hv_pmos ad=5.4312p pd=15.6u as=5.4312p ps=15.6u w=4.36u l=0.4u
X643 A GATE B A sg13_hv_pmos ad=5.4312p pd=15.6u as=5.4312p ps=15.6u w=4.36u l=0.4u
X644 A GATE B A sg13_hv_pmos ad=5.4312p pd=15.6u as=5.4312p ps=15.6u w=4.36u l=0.4u
X645 B GATE A A sg13_hv_pmos ad=5.4312p pd=15.6u as=5.4312p ps=15.6u w=4.36u l=0.4u
X646 B GATE A A sg13_hv_pmos ad=5.4312p pd=15.6u as=5.4312p ps=15.6u w=4.36u l=0.4u
X647 A GATE B A sg13_hv_pmos ad=5.4312p pd=15.6u as=5.4312p ps=15.6u w=4.36u l=0.4u
X648 B GATE A A sg13_hv_pmos ad=5.4312p pd=15.6u as=5.4312p ps=15.6u w=4.36u l=0.4u
X649 A GATE B A sg13_hv_pmos ad=5.4312p pd=15.6u as=5.4312p ps=15.6u w=4.36u l=0.4u
X650 B GATE A A sg13_hv_pmos ad=5.4312p pd=15.6u as=5.4312p ps=15.6u w=4.36u l=0.4u
X651 A GATE B A sg13_hv_pmos ad=5.4312p pd=15.6u as=5.4312p ps=15.6u w=4.36u l=0.4u
X652 A GATE B A sg13_hv_pmos ad=5.4312p pd=15.6u as=5.4312p ps=15.6u w=4.36u l=0.4u
X653 A GATE B A sg13_hv_pmos ad=5.4312p pd=15.6u as=5.4312p ps=15.6u w=4.36u l=0.4u
X654 A GATE B A sg13_hv_pmos ad=5.4312p pd=15.6u as=5.4312p ps=15.6u w=4.36u l=0.4u
X655 A GATE B A sg13_hv_pmos ad=5.4312p pd=15.6u as=5.4312p ps=15.6u w=4.36u l=0.4u
X656 B GATE A A sg13_hv_pmos ad=5.4312p pd=15.6u as=5.4312p ps=15.6u w=4.36u l=0.4u
X657 B GATE A A sg13_hv_pmos ad=5.4312p pd=15.6u as=3.052p ps=10.12u w=4.36u l=0.4u
X658 B GATE A A sg13_hv_pmos ad=5.4312p pd=15.6u as=5.4312p ps=15.6u w=4.36u l=0.4u
X659 B GATE A A sg13_hv_pmos ad=5.4312p pd=15.6u as=5.4312p ps=15.6u w=4.36u l=0.4u
X660 A GATE B A sg13_hv_pmos ad=5.4312p pd=15.6u as=5.4312p ps=15.6u w=4.36u l=0.4u
X661 B GATE A A sg13_hv_pmos ad=5.4312p pd=15.6u as=5.4312p ps=15.6u w=4.36u l=0.4u
X662 A GATE B A sg13_hv_pmos ad=5.4312p pd=15.6u as=5.4312p ps=15.6u w=4.36u l=0.4u
X663 B GATE A A sg13_hv_pmos ad=5.4312p pd=15.6u as=3.052p ps=10.12u w=4.36u l=0.4u
X664 A GATE B A sg13_hv_pmos ad=5.4312p pd=15.6u as=5.4312p ps=15.6u w=4.36u l=0.4u
X665 A GATE B A sg13_hv_pmos ad=5.4312p pd=15.6u as=5.4312p ps=15.6u w=4.36u l=0.4u
X666 A GATE B A sg13_hv_pmos ad=5.4312p pd=15.6u as=5.4312p ps=15.6u w=4.36u l=0.4u
X667 B GATE A A sg13_hv_pmos ad=5.4312p pd=15.6u as=5.4312p ps=15.6u w=4.36u l=0.4u
X668 A GATE B A sg13_hv_pmos ad=5.4312p pd=15.6u as=5.4312p ps=15.6u w=4.36u l=0.4u
X669 B GATE A A sg13_hv_pmos ad=5.4312p pd=15.6u as=5.4312p ps=15.6u w=4.36u l=0.4u
X670 B GATE A A sg13_hv_pmos ad=5.4312p pd=15.6u as=5.4312p ps=15.6u w=4.36u l=0.4u
X671 B GATE A A sg13_hv_pmos ad=5.4312p pd=15.6u as=5.4312p ps=15.6u w=4.36u l=0.4u
X672 A GATE B A sg13_hv_pmos ad=5.4312p pd=15.6u as=5.4312p ps=15.6u w=4.36u l=0.4u
X673 B GATE A A sg13_hv_pmos ad=5.4312p pd=15.6u as=5.4312p ps=15.6u w=4.36u l=0.4u
X674 A GATE B A sg13_hv_pmos ad=5.4312p pd=15.6u as=5.4312p ps=15.6u w=4.36u l=0.4u
X675 A GATE B A sg13_hv_pmos ad=5.4312p pd=15.6u as=5.4312p ps=15.6u w=4.36u l=0.4u
X676 B GATE A A sg13_hv_pmos ad=5.4312p pd=15.6u as=5.4312p ps=15.6u w=4.36u l=0.4u
X677 B GATE A A sg13_hv_pmos ad=5.4312p pd=15.6u as=5.4312p ps=15.6u w=4.36u l=0.4u
X678 B GATE A A sg13_hv_pmos ad=5.4312p pd=15.6u as=5.4312p ps=15.6u w=4.36u l=0.4u
X679 B GATE A A sg13_hv_pmos ad=5.4312p pd=15.6u as=5.4312p ps=15.6u w=4.36u l=0.4u
X680 B GATE A A sg13_hv_pmos ad=5.4312p pd=15.6u as=5.4312p ps=15.6u w=4.36u l=0.4u
X681 A GATE B A sg13_hv_pmos ad=5.4312p pd=15.6u as=5.4312p ps=15.6u w=4.36u l=0.4u
X682 A GATE B A sg13_hv_pmos ad=5.4312p pd=15.6u as=5.4312p ps=15.6u w=4.36u l=0.4u
X683 B GATE A A sg13_hv_pmos ad=3.052p pd=10.12u as=5.4312p ps=15.6u w=4.36u l=0.4u
X684 A GATE B A sg13_hv_pmos ad=5.4312p pd=15.6u as=5.4312p ps=15.6u w=4.36u l=0.4u
X685 B GATE A A sg13_hv_pmos ad=5.4312p pd=15.6u as=5.4312p ps=15.6u w=4.36u l=0.4u
X686 A GATE B A sg13_hv_pmos ad=5.4312p pd=15.6u as=5.4312p ps=15.6u w=4.36u l=0.4u
X687 A GATE B A sg13_hv_pmos ad=5.4312p pd=15.6u as=3.052p ps=10.12u w=4.36u l=0.4u
X688 B GATE A A sg13_hv_pmos ad=5.4312p pd=15.6u as=5.4312p ps=15.6u w=4.36u l=0.4u
X689 B GATE A A sg13_hv_pmos ad=5.4312p pd=15.6u as=5.4312p ps=15.6u w=4.36u l=0.4u
X690 B GATE A A sg13_hv_pmos ad=5.4312p pd=15.6u as=5.4312p ps=15.6u w=4.36u l=0.4u
X691 B GATE A A sg13_hv_pmos ad=5.4312p pd=15.6u as=5.4312p ps=15.6u w=4.36u l=0.4u
X692 A GATE B A sg13_hv_pmos ad=5.4312p pd=15.6u as=5.4312p ps=15.6u w=4.36u l=0.4u
X693 A GATE B A sg13_hv_pmos ad=5.4312p pd=15.6u as=5.4312p ps=15.6u w=4.36u l=0.4u
X694 A GATE B A sg13_hv_pmos ad=5.4312p pd=15.6u as=5.4312p ps=15.6u w=4.36u l=0.4u
X695 B GATE A A sg13_hv_pmos ad=5.4312p pd=15.6u as=5.4312p ps=15.6u w=4.36u l=0.4u
X696 A GATE B A sg13_hv_pmos ad=5.4312p pd=15.6u as=5.4312p ps=15.6u w=4.36u l=0.4u
X697 B GATE A A sg13_hv_pmos ad=5.4312p pd=15.6u as=5.4312p ps=15.6u w=4.36u l=0.4u
X698 B GATE A A sg13_hv_pmos ad=5.4312p pd=15.6u as=5.4312p ps=15.6u w=4.36u l=0.4u
X699 B GATE A A sg13_hv_pmos ad=5.4312p pd=15.6u as=5.4312p ps=15.6u w=4.36u l=0.4u
X700 B GATE A A sg13_hv_pmos ad=5.4312p pd=15.6u as=3.052p ps=10.12u w=4.36u l=0.4u
X701 A GATE B A sg13_hv_pmos ad=5.4312p pd=15.6u as=5.4312p ps=15.6u w=4.36u l=0.4u
X702 A GATE B A sg13_hv_pmos ad=5.4312p pd=15.6u as=5.4312p ps=15.6u w=4.36u l=0.4u
X703 A GATE B A sg13_hv_pmos ad=5.4312p pd=15.6u as=5.4312p ps=15.6u w=4.36u l=0.4u
X704 A GATE B A sg13_hv_pmos ad=5.4312p pd=15.6u as=5.4312p ps=15.6u w=4.36u l=0.4u
X705 B GATE A A sg13_hv_pmos ad=5.4312p pd=15.6u as=5.4312p ps=15.6u w=4.36u l=0.4u
X706 A GATE B A sg13_hv_pmos ad=3.052p pd=10.12u as=5.4312p ps=15.6u w=4.36u l=0.4u
X707 B GATE A A sg13_hv_pmos ad=5.4312p pd=15.6u as=5.4312p ps=15.6u w=4.36u l=0.4u
X708 B GATE A A sg13_hv_pmos ad=5.4312p pd=15.6u as=5.4312p ps=15.6u w=4.36u l=0.4u
X709 A GATE B A sg13_hv_pmos ad=5.4312p pd=15.6u as=5.4312p ps=15.6u w=4.36u l=0.4u
X710 A GATE B A sg13_hv_pmos ad=5.4312p pd=15.6u as=5.4312p ps=15.6u w=4.36u l=0.4u
X711 A GATE B A sg13_hv_pmos ad=5.4312p pd=15.6u as=5.4312p ps=15.6u w=4.36u l=0.4u
X712 B GATE A A sg13_hv_pmos ad=5.4312p pd=15.6u as=3.052p ps=10.12u w=4.36u l=0.4u
X713 A GATE B A sg13_hv_pmos ad=5.4312p pd=15.6u as=5.4312p ps=15.6u w=4.36u l=0.4u
X714 B GATE A A sg13_hv_pmos ad=5.4312p pd=15.6u as=5.4312p ps=15.6u w=4.36u l=0.4u
X715 B GATE A A sg13_hv_pmos ad=5.4312p pd=15.6u as=5.4312p ps=15.6u w=4.36u l=0.4u
X716 B GATE A A sg13_hv_pmos ad=5.4312p pd=15.6u as=5.4312p ps=15.6u w=4.36u l=0.4u
X717 B GATE A A sg13_hv_pmos ad=5.4312p pd=15.6u as=5.4312p ps=15.6u w=4.36u l=0.4u
X718 A GATE B A sg13_hv_pmos ad=5.4312p pd=15.6u as=5.4312p ps=15.6u w=4.36u l=0.4u
X719 B GATE A A sg13_hv_pmos ad=5.4312p pd=15.6u as=5.4312p ps=15.6u w=4.36u l=0.4u
X720 A GATE B A sg13_hv_pmos ad=5.4312p pd=15.6u as=5.4312p ps=15.6u w=4.36u l=0.4u
X721 A GATE B A sg13_hv_pmos ad=5.4312p pd=15.6u as=5.4312p ps=15.6u w=4.36u l=0.4u
X722 B GATE A A sg13_hv_pmos ad=5.4312p pd=15.6u as=5.4312p ps=15.6u w=4.36u l=0.4u
X723 B GATE A A sg13_hv_pmos ad=5.4312p pd=15.6u as=5.4312p ps=15.6u w=4.36u l=0.4u
X724 B GATE A A sg13_hv_pmos ad=5.4312p pd=15.6u as=5.4312p ps=15.6u w=4.36u l=0.4u
X725 B GATE A A sg13_hv_pmos ad=5.4312p pd=15.6u as=5.4312p ps=15.6u w=4.36u l=0.4u
X726 A GATE B A sg13_hv_pmos ad=5.4312p pd=15.6u as=5.4312p ps=15.6u w=4.36u l=0.4u
X727 B GATE A A sg13_hv_pmos ad=3.052p pd=10.12u as=5.4312p ps=15.6u w=4.36u l=0.4u
X728 A GATE B A sg13_hv_pmos ad=5.4312p pd=15.6u as=5.4312p ps=15.6u w=4.36u l=0.4u
X729 B GATE A A sg13_hv_pmos ad=5.4312p pd=15.6u as=5.4312p ps=15.6u w=4.36u l=0.4u
X730 B GATE A A sg13_hv_pmos ad=5.4312p pd=15.6u as=5.4312p ps=15.6u w=4.36u l=0.4u
X731 A GATE B A sg13_hv_pmos ad=5.4312p pd=15.6u as=3.052p ps=10.12u w=4.36u l=0.4u
X732 B GATE A A sg13_hv_pmos ad=5.4312p pd=15.6u as=5.4312p ps=15.6u w=4.36u l=0.4u
X733 B GATE A A sg13_hv_pmos ad=5.4312p pd=15.6u as=5.4312p ps=15.6u w=4.36u l=0.4u
X734 A GATE B A sg13_hv_pmos ad=5.4312p pd=15.6u as=5.4312p ps=15.6u w=4.36u l=0.4u
X735 A GATE B A sg13_hv_pmos ad=5.4312p pd=15.6u as=5.4312p ps=15.6u w=4.36u l=0.4u
X736 A GATE B A sg13_hv_pmos ad=5.4312p pd=15.6u as=5.4312p ps=15.6u w=4.36u l=0.4u
X737 B GATE A A sg13_hv_pmos ad=5.4312p pd=15.6u as=5.4312p ps=15.6u w=4.36u l=0.4u
X738 A GATE B A sg13_hv_pmos ad=5.4312p pd=15.6u as=5.4312p ps=15.6u w=4.36u l=0.4u
X739 B GATE A A sg13_hv_pmos ad=5.4312p pd=15.6u as=5.4312p ps=15.6u w=4.36u l=0.4u
X740 A GATE B A sg13_hv_pmos ad=5.4312p pd=15.6u as=5.4312p ps=15.6u w=4.36u l=0.4u
X741 A GATE B A sg13_hv_pmos ad=5.4312p pd=15.6u as=5.4312p ps=15.6u w=4.36u l=0.4u
X742 A GATE B A sg13_hv_pmos ad=3.052p pd=10.12u as=5.4312p ps=15.6u w=4.36u l=0.4u
X743 B GATE A A sg13_hv_pmos ad=5.4312p pd=15.6u as=5.4312p ps=15.6u w=4.36u l=0.4u
X744 A GATE B A sg13_hv_pmos ad=5.4312p pd=15.6u as=5.4312p ps=15.6u w=4.36u l=0.4u
X745 B GATE A A sg13_hv_pmos ad=5.4312p pd=15.6u as=5.4312p ps=15.6u w=4.36u l=0.4u
X746 B GATE A A sg13_hv_pmos ad=5.4312p pd=15.6u as=3.052p ps=10.12u w=4.36u l=0.4u
X747 A GATE B A sg13_hv_pmos ad=5.4312p pd=15.6u as=5.4312p ps=15.6u w=4.36u l=0.4u
X748 B GATE A A sg13_hv_pmos ad=5.4312p pd=15.6u as=5.4312p ps=15.6u w=4.36u l=0.4u
X749 A GATE B A sg13_hv_pmos ad=5.4312p pd=15.6u as=3.052p ps=10.12u w=4.36u l=0.4u
X750 B GATE A A sg13_hv_pmos ad=5.4312p pd=15.6u as=5.4312p ps=15.6u w=4.36u l=0.4u
X751 A GATE B A sg13_hv_pmos ad=5.4312p pd=15.6u as=5.4312p ps=15.6u w=4.36u l=0.4u
X752 B GATE A A sg13_hv_pmos ad=5.4312p pd=15.6u as=5.4312p ps=15.6u w=4.36u l=0.4u
X753 B GATE A A sg13_hv_pmos ad=5.4312p pd=15.6u as=5.4312p ps=15.6u w=4.36u l=0.4u
X754 A GATE B A sg13_hv_pmos ad=5.4312p pd=15.6u as=5.4312p ps=15.6u w=4.36u l=0.4u
X755 A GATE B A sg13_hv_pmos ad=5.4312p pd=15.6u as=5.4312p ps=15.6u w=4.36u l=0.4u
X756 A GATE B A sg13_hv_pmos ad=5.4312p pd=15.6u as=5.4312p ps=15.6u w=4.36u l=0.4u
X757 B GATE A A sg13_hv_pmos ad=3.052p pd=10.12u as=5.4312p ps=15.6u w=4.36u l=0.4u
X758 B GATE A A sg13_hv_pmos ad=5.4312p pd=15.6u as=5.4312p ps=15.6u w=4.36u l=0.4u
X759 B GATE A A sg13_hv_pmos ad=5.4312p pd=15.6u as=5.4312p ps=15.6u w=4.36u l=0.4u
.ends

.subckt sg13cmos5l_inv_4 Y A VDD VSS
X0 Y A VSS VSS sg13_lv_nmos ad=0.1406p pd=1.12u as=0.2516p ps=2.16u w=0.74u l=0.13u
X1 Y A VDD VDD sg13_lv_pmos ad=0.2128p pd=1.5u as=0.3808p ps=2.92u w=1.12u l=0.13u
X2 VSS A Y VSS sg13_lv_nmos ad=0.1406p pd=1.12u as=0.1406p ps=1.12u w=0.74u l=0.13u
X3 Y A VSS VSS sg13_lv_nmos ad=0.1406p pd=1.12u as=0.1406p ps=1.12u w=0.74u l=0.13u
X4 VDD A Y VDD sg13_lv_pmos ad=0.2128p pd=1.5u as=0.2128p ps=1.5u w=1.12u l=0.13u
X5 VSS A Y VSS sg13_lv_nmos ad=0.2516p pd=2.16u as=0.1406p ps=1.12u w=0.74u l=0.13u
X6 Y A VDD VDD sg13_lv_pmos ad=0.2128p pd=1.5u as=0.2128p ps=1.5u w=1.12u l=0.13u
X7 VDD A Y VDD sg13_lv_pmos ad=0.3808p pd=2.92u as=0.2128p ps=1.5u w=1.12u l=0.13u
.ends

.subckt power_stage IOVDD_IN IOVDD_OUT DVDD DVSS IOVSS enable
Xgate_drive_0 gate_drive_0/in_p gate_drive_0/in_n IOVSS IOVDD_IN gate_drive_0/out
+ gate_drive
Xsg13cmos5l_antennanp_0 enable DVDD DVSS sg13cmos5l_antennanp
Xsg13cmos5l_decap_4_0 DVDD DVSS sg13cmos5l_decap_4
Xsg13cmos5l_decap_4_1 DVDD DVSS sg13cmos5l_decap_4
Xpmos_waffle_20_0 IOVDD_OUT IOVDD_IN IOVSS gate_drive_0/out pmos_waffle_20
Xsg13cmos5l_inv_4_0 gate_drive_0/in_n enable DVDD DVSS sg13cmos5l_inv_4
Xsg13cmos5l_inv_4_1 gate_drive_0/in_p gate_drive_0/in_n DVDD DVSS sg13cmos5l_inv_4
.ends
